# Ansys Electronics Desktop project, version 2020.2
project variables:
  $r = max($position_y_touch,max($position_x_touch,$position_sweetspot_touch))+$move_r
  $mag_bredth = 10mm
  $mag_width = 10mm
  $mag_length = 10mm
  $Angle_between = 0.39269908rad
  $angle1 = ($Angle_between*1*2) rad
  $angle2 = ($Angle_between*2*2) rad
  $angle3 = ($Angle_between*3*2) rad
  $angle4 = ($Angle_between*4*2) rad
  $angle5 = ($Angle_between*5*2) rad
  $angle6 = ($Angle_between*6*2) rad
  $angle7 = ($Angle_between*7*2) rad
  $angle8 = ($Angle_between*8*2) rad
  $angle9 = ($Angle_between*9*2) rad
  $angle10 = ($Angle_between*10*2) rad
  $angle11 = ($Angle_between*11*2) rad
  $angle12 = ($Angle_between*12*2) rad
  $angle13 = ($Angle_between*13*2) rad
  $angle14 = ($Angle_between*14*2) rad
  $angle15 = ($Angle_between*15*2) rad
  $sweet_spot = 40mm
  $swet_spot_length = 30mm
  $length_between_row = 1mm
  $num_of_rows = 5
  $buffer = 10
  $num_of_sheets = 15
  $length_between_sheet = ((($num_of_rows-1)*$length_between_row)+$mag_length)/$num_of_sheets
  $move_r = 2mm
  $position_x_touch = ($mag_bredth+(cos($angle1)*($mag_width+$mag_bredth)))/(2*sin($Angle_between))
  $position_y_touch = ($mag_width+(cos($angle1)*($mag_width+$mag_bredth)))/(2*sin($Angle_between))
  $position_sweetspot_touch = sqrt(2*sqr($sweet_spot/2))+sqrt(sqr($mag_width/2)+sqr($mag_bredth/2))
materials:
  vacuum: permittivity=1
  NdFe30: permittivity=1 permeability=1.044573 conductivity=625000 magnetic_coercivity{Magnitude=-838000A_per_meter DirComp1=1 DirComp2=0 DirComp3=0} lande_g_factor=2

design Maxwell3DDesign1 (Maxwell 3D, Magnetostatic, model units mm)
geometry:
  coordinate_system RelativeCS0 = origin=($r*cos($Angle_between*0), $r*sin($Angle_between*0), 0mm) x=(cos(0) mm, sin(0) mm, 0mm) y=(-sin(0) mm, cos(0) mm, 0mm)
  Box0 [NdFe30] = box(corner=(-$mag_bredth/2, -$mag_width/2, -$mag_length/2), size=($mag_bredth, $mag_width, $mag_length)) in RelativeCS0
  coordinate_system RelativeCS1 = origin=($r*cos($Angle_between*1), $r*sin($Angle_between*1), 0mm) x=(cos($angle1), sin($angle1), 0mm) y=(-sin($angle1), cos($angle1), 0mm)
  Box1 [NdFe30, oriented by RelativeCS1] = box(corner=(-$mag_bredth/2, -$mag_width/2, -$mag_length/2), size=($mag_bredth, $mag_width, $mag_length)) in RelativeCS1
  coordinate_system RelativeCS2 = origin=($r*cos($Angle_between*2), $r*sin($Angle_between*2), 0mm) x=(cos($angle2), sin($angle2), 0mm) y=(-sin($angle2), cos($angle2), 0mm)
  Box2 [NdFe30, oriented by RelativeCS2] = box(corner=(-$mag_bredth/2, -$mag_width/2, -$mag_length/2), size=($mag_bredth, $mag_width, $mag_length)) in RelativeCS2
  coordinate_system RelativeCS3 = origin=($r*cos($Angle_between*3), $r*sin($Angle_between*3), 0mm) x=(cos($angle3), sin($angle3), 0mm) y=(-sin($angle3), cos($angle3), 0mm)
  Box3 [NdFe30, oriented by RelativeCS3] = box(corner=(-$mag_bredth/2, -$mag_width/2, -$mag_length/2), size=($mag_bredth, $mag_width, $mag_length)) in RelativeCS3
  coordinate_system RelativeCS4 = origin=($r*cos($Angle_between*4), $r*sin($Angle_between*4), 0mm) x=(cos($angle4), sin($angle4), 0mm) y=(-sin($angle4), cos($angle4), 0mm)
  Box4 [NdFe30, oriented by RelativeCS4] = box(corner=(-$mag_bredth/2, -$mag_width/2, -$mag_length/2), size=($mag_bredth, $mag_width, $mag_length)) in RelativeCS4
  coordinate_system RelativeCS5 = origin=($r*cos($Angle_between*5), $r*sin($Angle_between*5), 0mm) x=(cos($angle5), sin($angle5), 0mm) y=(-5mm, 45mm, 0mm)
  Box5 [NdFe30, oriented by RelativeCS5] = box(corner=(-$mag_bredth/2, -$mag_width/2, -$mag_length/2), size=($mag_bredth, $mag_width, $mag_length)) in RelativeCS5
  coordinate_system RelativeCS6 = origin=($r*cos($Angle_between*6), $r*sin($Angle_between*6), 0mm) x=(cos($angle6), sin($angle6), 0mm) y=(-sin($angle6), cos($angle6), 0mm)
  Box6 [NdFe30, oriented by RelativeCS6] = box(corner=(-$mag_bredth/2, -$mag_width/2, -$mag_length/2), size=($mag_bredth, $mag_width, $mag_length)) in RelativeCS6
  coordinate_system RelativeCS7 = origin=($r*cos($Angle_between*7), $r*sin($Angle_between*7), 0mm) x=(cos($angle7), sin($angle7), 0mm) y=(-sin($angle7), cos($angle7), 0mm)
  Box7 [NdFe30, oriented by RelativeCS7] = box(corner=(-$mag_bredth/2, -$mag_width/2, -$mag_length/2), size=($mag_bredth, $mag_width, $mag_length)) in RelativeCS7
  coordinate_system RelativeCS8 = origin=($r*cos($Angle_between*8), $r*sin($Angle_between*8), 0mm) x=(cos($angle8), sin($angle8), 0mm) y=(-sin($angle8), cos($angle8), 0mm)
  Box8 [NdFe30, oriented by RelativeCS8] = box(corner=(-$mag_bredth/2, -$mag_width/2, -$mag_length/2), size=($mag_bredth, $mag_width, $mag_length)) in RelativeCS8
  coordinate_system RelativeCS9 = origin=($r*cos($Angle_between*9), $r*sin($Angle_between*9), 0mm) x=(cos($angle9), sin($angle9), 0mm) y=(-sin($angle9), cos($angle9), 0mm)
  Box9 [NdFe30, oriented by RelativeCS9] = box(corner=(-$mag_bredth/2, -$mag_width/2, -$mag_length/2), size=($mag_bredth, $mag_width, $mag_length)) in RelativeCS9
  coordinate_system RelativeCS10 = origin=($r*cos($Angle_between*10), $r*sin($Angle_between*10), 0mm) x=(cos($angle10), sin($angle10), 0mm) y=(-sin($angle10), cos($angle10), 0mm)
  Box10 [NdFe30, oriented by RelativeCS10] = box(corner=(-$mag_bredth/2, -$mag_width/2, -$mag_length/2), size=($mag_bredth, $mag_width, $mag_length)) in RelativeCS10
  coordinate_system RelativeCS11 = origin=($r*cos($Angle_between*11), $r*sin($Angle_between*11), 0mm) x=(cos($angle11), sin($angle11), 0mm) y=(-sin($angle11), cos($angle11), 0mm)
  Box11 [NdFe30, oriented by RelativeCS11] = box(corner=(-$mag_bredth/2, -$mag_width/2, -$mag_length/2), size=($mag_bredth, $mag_width, $mag_length)) in RelativeCS11
  coordinate_system RelativeCS12 = origin=($r*cos($Angle_between*12), $r*sin($Angle_between*12), 0mm) x=(cos($angle12), sin($angle12), 0mm) y=(-sin($angle12), cos($angle12), 0mm)
  Box12 [NdFe30, oriented by RelativeCS12] = box(corner=(-$mag_bredth/2, -$mag_width/2, -$mag_length/2), size=($mag_bredth, $mag_width, $mag_length)) in RelativeCS12
  coordinate_system RelativeCS13 = origin=($r*cos($Angle_between*13), $r*sin($Angle_between*13), 0mm) x=(cos($angle13), sin($angle13), 0mm) y=(-sin($angle13), cos($angle13), 0mm)
  Box13 [NdFe30, oriented by RelativeCS13] = box(corner=(-$mag_bredth/2, -$mag_width/2, -$mag_length/2), size=($mag_bredth, $mag_width, $mag_length)) in RelativeCS13
  coordinate_system RelativeCS14 = origin=($r*cos($Angle_between*14), $r*sin($Angle_between*14), 0mm) x=(cos($angle14), sin($angle14), 0mm) y=(-sin($angle14), cos($angle14), 0mm)
  Box14 [NdFe30, oriented by RelativeCS14] = box(corner=(-$mag_bredth/2, -$mag_width/2, -$mag_length/2), size=($mag_bredth, $mag_width, $mag_length)) in RelativeCS14
  coordinate_system RelativeCS15 = origin=($r*cos($Angle_between*15), $r*sin($Angle_between*15), 0mm) x=(cos($angle15), sin($angle15), 0mm) y=(-sin($angle15), cos($angle15), 0mm)
  Box15 [NdFe30, oriented by RelativeCS15] = box(corner=(-$mag_bredth/2, -$mag_width/2, -$mag_length/2), size=($mag_bredth, $mag_width, $mag_length)) in RelativeCS15
  coordinate_system center = origin=(0mm, 0mm, ($num_of_rows*$mag_length+(($num_of_rows-1)*$length_between_row))/2-$mag_length/2) x=(1mm, 0mm, 0mm) y=(0mm, 1mm, 0mm)
  sweet_spot_box [vacuum, non-model, oriented by center] = box(corner=(0, 0, -$swet_spot_length/2), size=($sweet_spot/2, $sweet_spot/2, $swet_spot_length)) in center
  Rectangle1 [non-model] = rectangle(corner=(-($r+$buffer), -($r+$buffer), -$mag_length/2), x_size=($r+$buffer)*2, y_size=($r+$buffer)*2)
  Rectangle1_1..Rectangle1_15 [non-model] = Rectangle1.duplicate_along_line(step=(0mm, 0mm, $length_between_sheet), total=16) in center
  Region [vacuum] = region(percentage_offset=400 on all sides) in center
  point Point1 = (-110000mm, -90000mm, 0mm)
  Box0_1..Box0_4 [NdFe30] = Box0.duplicate_along_line(step=(0mm, 0mm, $mag_length+$length_between_row), total=5)
  Box1_1..Box1_4 [NdFe30, oriented by RelativeCS1] = Box1.duplicate_along_line(step=(0mm, 0mm, $mag_length+$length_between_row), total=5)
  Box2_1..Box2_4 [NdFe30, oriented by RelativeCS2] = Box2.duplicate_along_line(step=(0mm, 0mm, $mag_length+$length_between_row), total=5)
  Box3_1..Box3_4 [NdFe30, oriented by RelativeCS3] = Box3.duplicate_along_line(step=(0mm, 0mm, $mag_length+$length_between_row), total=5)
  Box4_1..Box4_4 [NdFe30, oriented by RelativeCS4] = Box4.duplicate_along_line(step=(0mm, 0mm, $mag_length+$length_between_row), total=5)
  Box5_1..Box5_4 [NdFe30, oriented by RelativeCS5] = Box5.duplicate_along_line(step=(0mm, 0mm, $mag_length+$length_between_row), total=5)
  Box6_1..Box6_4 [NdFe30, oriented by RelativeCS6] = Box6.duplicate_along_line(step=(0mm, 0mm, $mag_length+$length_between_row), total=5)
  Box7_1..Box7_4 [NdFe30, oriented by RelativeCS7] = Box7.duplicate_along_line(step=(0mm, 0mm, $mag_length+$length_between_row), total=5)
  Box8_1..Box8_4 [NdFe30, oriented by RelativeCS8] = Box8.duplicate_along_line(step=(0mm, 0mm, $mag_length+$length_between_row), total=5)
  Box9_1..Box9_4 [NdFe30, oriented by RelativeCS9] = Box9.duplicate_along_line(step=(0mm, 0mm, $mag_length+$length_between_row), total=5)
  Box10_1..Box10_4 [NdFe30, oriented by RelativeCS10] = Box10.duplicate_along_line(step=(0mm, 0mm, $mag_length+$length_between_row), total=5)
  Box11_1..Box11_4 [NdFe30, oriented by RelativeCS11] = Box11.duplicate_along_line(step=(0mm, 0mm, $mag_length+$length_between_row), total=5)
  Box12_1..Box12_4 [NdFe30, oriented by RelativeCS12] = Box12.duplicate_along_line(step=(0mm, 0mm, $mag_length+$length_between_row), total=5)
  Box13_1..Box13_4 [NdFe30, oriented by RelativeCS13] = Box13.duplicate_along_line(step=(0mm, 0mm, $mag_length+$length_between_row), total=5)
  Box14_1..Box14_4 [NdFe30, oriented by RelativeCS14] = Box14.duplicate_along_line(step=(0mm, 0mm, $mag_length+$length_between_row), total=5)
  Box15_1..Box15_4 [NdFe30, oriented by RelativeCS15] = Box15.duplicate_along_line(step=(0mm, 0mm, $mag_length+$length_between_row), total=5)
  coordinate_system sph_1_0 = origin=($r*cos($Angle_between*0)*cos($Angle_between*1), $r*sin($Angle_between*0), -$r*cos($Angle_between*0)*sin($Angle_between*1)) x=(1, 0, -sin($angle1)) y=(0, 1, 0)
  coordinate_system sph_2_0 = origin=($r*cos($Angle_between*0)*cos($Angle_between*2), $r*sin($Angle_between*0), -$r*cos($Angle_between*0)*sin($Angle_between*2)) x=(1mm, 0mm, -sin($angle1)) y=(0mm, 1mm, 0mm)
  group Box_Group = Box0..Box15, Box0_1..Box0_4, Box1_1..Box1_4, Box2_1..Box2_4, Box3_1..Box3_4, Box4_1..Box4_4, Box5_1..Box5_4, Box6_1..Box6_4, Box7_1..Box7_4, Box8_1..Box8_4, Box9_1..Box9_4, Box10_1..Box10_4, Box11_1..Box11_4, Box12_1..Box12_4, Box13_1..Box13_4, Box14_1..Box14_4, Box15_1..Box15_4
  group Rectangle_Group = Rectangle1, Rectangle1_1..Rectangle1_15
mesh:
  Length1: LengthBased Objects=[Box0..Box15] NumMaxElem=10000
  initial mesh: GlobalCurvilinear{Apply}
setups:
  solution1: Magnetostatic MaximumPasses=10 MinimumPasses=2 MinimumConvergedPasses=1 PercentRefinement=30 PercentError=1 NonLinearResidual=0.001 SmoothBHCurve
optimetrics:
  ParametricSetup1: Parametric disabled Sim._Setups=[solution1]
    sweep $move_r: LIN 0mm 24mm 6mm
    sweep $length_between_row: LIN 1mm 3mm 1mm
    calculate mean on solution1 : LastAdaptive
    calculate dif on solution1 : LastAdaptive
  ParametricSetup2: Parametric disabled Sim._Setups=[solution1]
    sweep $move_r: LIN 18mm 24mm 2mm
    calculate mean on solution1 : LastAdaptive
    calculate dif on solution1 : LastAdaptive
  ParametricSetup3: Parametric disabled Sim._Setups=[solution1]
    sweep $move_r: LIN 18mm 24mm 2mm
    calculate mean on solution1 : LastAdaptive
    calculate dif on solution1 : LastAdaptive
  ParametricSetup4: Parametric disabled Sim._Setups=[solution1]
    sweep $move_r: LIN 19mm 21mm 0.5mm
    calculate mean on solution1 : LastAdaptive
    calculate dif on solution1 : LastAdaptive
  ParametricSetup5: Parametric disabled Sim._Setups=[solution1]
    sweep $move_r: LIN 21mm 23mm 0.2mm
    calculate dif on solution1 : LastAdaptive
    calculate mean on solution1 : LastAdaptive
  ParametricSetup6: Parametric disabled Sim._Setups=[solution1]
    sweep $move_r: LIN 20.8mm 21.2mm 0.05mm
    calculate mean on solution1 : LastAdaptive
    calculate dif on solution1 : LastAdaptive
  DefaultDesignXplorerSetup: DesignExplorer Sim._Setups=[solution1] CostFunctionName=Cost CostFuncNormType=L2
    sweep $length_between_row: 1mm
    sweep $move_r: 2mm
    table edits: del(1mm, 2mm) add(0.425mm, 7mm)
    calculate mean on solution1 : LastAdaptive
    calculate dif on solution1 : LastAdaptive
field calculator expressions:
  mean = Mag_B | EnterVolume(sweet_spot_box) | VolumeValue | Mean
  min = Mag_B | EnterVolume(sweet_spot_box) | VolumeValue | Minimum
  max = Mag_B | EnterVolume(sweet_spot_box) | VolumeValue | Maximum
  dif = mean | min | - | Abs | mean | max | - | Abs | + | 2 | /
  x_component = Mag_B | VecX | ScalarX | EnterVolume(sweet_spot_box) | VolumeValue | Integrate | 48000 | /
reports:
  Calculator Expressions Table 2: dif, mean vs $move_r on solution1 : LastAdaptive [$length_between_row=all]
  Calculator Expressions Table 3: mean, dif vs $move_r on solution1 : LastAdaptive [$length_between_row=all $mag_bredth=all]
  Calculator Expressions Table 4: mean vs $mag_bredth on solution1 : LastAdaptive [$length_between_row=all $move_r=all]
  Calculator Expressions Table 5: mean, dif vs $move_r on solution1 : LastAdaptive [$length_between_row=all]
  Calculator Expressions Table 6: mean vs $mag_bredth on solution1 : LastAdaptive [$length_between_row=all $move_r=all]
  Calculator Expressions Table 7: mean, dif vs $move_r on solution1 : LastAdaptive [$length_between_row=all]
