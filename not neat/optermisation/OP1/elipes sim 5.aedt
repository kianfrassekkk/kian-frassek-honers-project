# Ansys Electronics Desktop project, version 2020.2
project variables:
  $num_mag_in_ring = 16
  $mag_bredth = 10mm
  $mag_width = 10mm
  $mag_length = 10mm
  $ratio_mod = 1
  $ratio = (max($mag_bredth,$mag_width)/min($mag_bredth,$mag_width))*$ratio_mod
  $Angle_between = 2*pi/$num_mag_in_ring
  $angle1 = $Angle_between*1
  $angle2 = $Angle_between*2
  $angle3 = $Angle_between*3
  $angle4 = $Angle_between*4
  $angle5 = $Angle_between*5
  $angle6 = $Angle_between*6
  $angle7 = $Angle_between*7
  $angle8 = $Angle_between*8
  $angle9 = $Angle_between*9
  $angle10 = $Angle_between*10
  $angle11 = $Angle_between*11
  $angle12 = $Angle_between*12
  $angle13 = $Angle_between*13
  $angle14 = $Angle_between*14
  $angle15 = $Angle_between*15
  $hieght = $r
  $width = $hieght*$ratio
  $rot_angle_around_x = 1*acos($width/$hieght) rad
  $angle_elips0 = 90
  $angle_elips1 = atan($width*sqrt($width**2*sin($angle1)**2)/($hieght*sqrt($width**2*cos($angle1)**2)))
  $angle_elips2 = atan($width*sqrt($width**2*sin($angle2)**2)/($hieght*sqrt($width**2*cos($angle2)**2)))
  $angle_elips3 = atan($width*sqrt($width**2*sin($angle3)**2)/($hieght*sqrt($width**2*cos($angle3)**2)))
  $angle_elips4 = $angle4
  $angle_elips5 = atan($width*sqrt($width**2*sin($angle5)**2)/($hieght*sqrt($width**2*cos($angle5)**2)))
  $angle_elips6 = atan($width*sqrt($width**2*sin($angle6)**2)/($hieght*sqrt($width**2*cos($angle6)**2)))
  $angle_elips7 = atan($width*sqrt($width**2*sin($angle7)**2)/($hieght*sqrt($width**2*cos($angle7)**2)))
  $angle_elips8 = $angle8
  $angle_elips9 = atan($width*sqrt($width**2*sin($angle9)**2)/($hieght*sqrt($width**2*cos($angle9)**2)))
  $angle_elips10 = atan($width*sqrt($width**2*sin($angle10)**2)/($hieght*sqrt($width**2*cos($angle10)**2)))
  $angle_elips11 = atan($width*sqrt($width**2*sin($angle11)**2)/($hieght*sqrt($width**2*cos($angle11)**2)))
  $angle_elips12 = $angle12
  $angle_elips13 = atan($width*sqrt($width**2*sin($angle13)**2)/($hieght*sqrt($width**2*cos($angle13)**2)))
  $angle_elips14 = atan($width*sqrt($width**2*sin($angle14)**2)/($hieght*sqrt($width**2*cos($angle14)**2)))
  $angle_elips15 = atan($width*sqrt($width**2*sin($angle15)**2)/($hieght*sqrt($width**2*cos($angle15)**2)))
  $position_sweetspot_touch = sqrt(2*sqr($sweet_spot/2))+sqrt(sqr($mag_width/2)+sqr($mag_bredth/2))
  $length_between_row = 11mm
  $swet_spot_length = 30mm
  $sweet_spot = 40mm
  $move_r = 0mm
  $num_of_sheets = 15
  $num_of_rows = 5
  $buffer = 0mm
  $length_between_sheet = ((($num_of_rows-1)*$length_between_row)+$mag_length)/$num_of_sheets
  $r = 60mm
  $position_y_touch = ($mag_width+(cos($angle1)*($mag_width+$mag_bredth)))/(2*sin($Angle_between))
  $position_x_touch = ($mag_bredth+(cos($angle1)*($mag_width+$mag_bredth)))/(2*sin($Angle_between))
materials:
  vacuum: permittivity=1
  NdFe30: permittivity=1 permeability=1.044573 conductivity=625000 magnetic_coercivity{Magnitude=-838000A_per_meter DirComp1=1 DirComp2=0 DirComp3=0} lande_g_factor=2
  air: permittivity=1.0006 permeability=1.0000004
  NdFe38: permittivity=1 permeability=1.0997785 conductivity=625000 magnetic_coercivity{Magnitude=-899000A_per_meter DirComp1=1 DirComp2=0 DirComp3=0} lande_g_factor=2

design Maxwell3DDesign1 (Maxwell 3D, Magnetostatic, model units mm)
geometry:
  coordinate_system RelativeCS0 = origin=(0, $hieght, 0mm) x=(cos(0) mm, sin(0) mm, 0mm) y=(-sin(0) mm, cos(0) mm, 0mm)
  Box0 [NdFe38, oriented by RelativeCS0] = box(corner=(-$mag_bredth/2, -$mag_width/2, -$mag_length/2), size=($mag_bredth, $mag_width, $mag_length)) in RelativeCS0
  coordinate_system RelativeCS1 = origin=(sqrt($width**2*sin($angle1)**2), $hieght*sqrt($width**2*cos($angle1)**2)/$width, 0) x=(cos(2*$angle_elips1), -sin(2*$angle_elips1), 0mm) y=(sin(2*$angle_elips1), cos(2*$angle_elips1), 0mm)
  Box1 [NdFe38, oriented by RelativeCS1] = box(corner=(-$mag_bredth/2, -$mag_width/2, -$mag_length/2), size=($mag_bredth, $mag_width, $mag_length)) in RelativeCS1
  coordinate_system RelativeCS2 = origin=(sqrt($width**2*sin($angle2)**2), $hieght*sqrt($width**2*cos($angle2)**2)/$width, 0) x=(cos(2*$angle_elips2), -sin(2*$angle_elips2), 0mm) y=(sin(2*$angle_elips2), cos(2*$angle_elips2), 0mm)
  Box2 [NdFe38, oriented by RelativeCS2] = box(corner=(-$mag_bredth/2, -$mag_width/2, -$mag_length/2), size=($mag_bredth, $mag_width, $mag_length)) in RelativeCS2
  coordinate_system RelativeCS3 = origin=(sqrt($width**2*sin($angle3)**2), $hieght*sqrt($width**2*cos($angle3)**2)/$width, 0) x=(cos(2*$angle_elips3), -sin(2*$angle_elips3), 0mm) y=(sin(2*$angle_elips3), cos(2*$angle_elips3), 0mm)
  Box3 [NdFe38, oriented by RelativeCS3] = box(corner=(-$mag_bredth/2, -$mag_width/2, -$mag_length/2), size=($mag_bredth, $mag_width, $mag_length)) in RelativeCS3
  coordinate_system RelativeCS4 = origin=($width, 0, 0mm) x=(cos(2*$angle4), sin(2*$angle4), 0mm) y=(-sin(2*$angle4), cos(2*$angle4), 0mm)
  Box4 [NdFe38, oriented by RelativeCS4] = box(corner=(-$mag_bredth/2, -$mag_width/2, -$mag_length/2), size=($mag_bredth, $mag_width, $mag_length)) in RelativeCS4
  coordinate_system RelativeCS5 = origin=(sqrt($width**2*sin($angle5)**2), -$hieght*sqrt($width**2*cos($angle5)**2)/$width, 0) x=(cos(2*$angle_elips5), sin(2*$angle_elips5), 0mm) y=(-sin(2*$angle_elips5), cos(2*$angle_elips5), 0mm)
  Box5 [NdFe38, oriented by RelativeCS5] = box(corner=(-$mag_bredth/2, -$mag_width/2, -$mag_length/2), size=($mag_bredth, $mag_width, $mag_length)) in RelativeCS5
  coordinate_system RelativeCS6 = origin=(sqrt($width**2*sin($angle6)**2), -$hieght*sqrt($width**2*cos($angle6)**2)/$width, 0) x=(cos(2*$angle_elips6), sin(2*$angle_elips6), 0mm) y=(-sin(2*$angle_elips6), cos(2*$angle_elips6), 0mm)
  Box6 [NdFe38, oriented by RelativeCS6] = box(corner=(-$mag_bredth/2, -$mag_width/2, -$mag_length/2), size=($mag_bredth, $mag_width, $mag_length)) in RelativeCS6
  coordinate_system RelativeCS7 = origin=(sqrt($width**2*sin($angle7)**2), -$hieght*sqrt($width**2*cos($angle7)**2)/$width, 0) x=(cos(2*$angle_elips7), sin(2*$angle_elips7), 0mm) y=(-sin(2*$angle_elips7), cos(2*$angle_elips7), 0mm)
  Box7 [NdFe38, oriented by RelativeCS7] = box(corner=(-$mag_bredth/2, -$mag_width/2, -$mag_length/2), size=($mag_bredth, $mag_width, $mag_length)) in RelativeCS7
  coordinate_system RelativeCS8 = origin=(0, -$hieght, 0) x=(cos(2*$angle8), -sin(2*$angle8), 0mm) y=(sin(2*$angle8), cos(2*$angle8), 0mm)
  Box8 [NdFe38, oriented by RelativeCS8] = box(corner=(-$mag_bredth/2, -$mag_width/2, -$mag_length/2), size=($mag_bredth, $mag_width, $mag_length)) in RelativeCS8
  coordinate_system RelativeCS9 = origin=(-sqrt($width**2*sin($angle9)**2), -$hieght*sqrt($width**2*cos($angle9)**2)/$width, 0) x=(cos(2*$angle_elips9), -sin(2*$angle_elips9), 0mm) y=(sin(2*$angle_elips9), cos(2*$angle_elips9), 0mm)
  Box9 [NdFe38, oriented by RelativeCS9] = box(corner=(-$mag_bredth/2, -$mag_width/2, -$mag_length/2), size=($mag_bredth, $mag_width, $mag_length)) in RelativeCS9
  coordinate_system RelativeCS10 = origin=(-sqrt($width**2*sin($angle10)**2), -$hieght*sqrt($width**2*cos($angle10)**2)/$width, 0) x=(cos(2*$angle_elips10), -sin(2*$angle_elips10), 0mm) y=(sin(2*$angle_elips10), cos(2*$angle_elips10), 0mm)
  Box10 [NdFe38, oriented by RelativeCS10] = box(corner=(-$mag_bredth/2, -$mag_width/2, -$mag_length/2), size=($mag_bredth, $mag_width, $mag_length)) in RelativeCS10
  coordinate_system RelativeCS11 = origin=(-sqrt($width**2*sin($angle11)**2), -$hieght*sqrt($width**2*cos($angle11)**2)/$width, 0) x=(cos(2*$angle_elips11), -sin(2*$angle_elips11), 0mm) y=(sin(2*$angle_elips11), cos(2*$angle_elips11), 0mm)
  Box11 [NdFe38, oriented by RelativeCS11] = box(corner=(-$mag_bredth/2, -$mag_width/2, -$mag_length/2), size=($mag_bredth, $mag_width, $mag_length)) in RelativeCS11
  coordinate_system RelativeCS12 = origin=(-$width, 0, 0) x=(cos(2*$angle12), -sin(2*$angle12), 0mm) y=(sin(2*$angle12), cos(2*$angle12), 0mm)
  Box12 [NdFe38, oriented by RelativeCS12] = box(corner=(-$mag_bredth/2, -$mag_width/2, -$mag_length/2), size=($mag_bredth, $mag_width, $mag_length)) in RelativeCS12
  coordinate_system RelativeCS13 = origin=(-sqrt($width**2*sin($angle13)**2), $hieght*sqrt($width**2*cos($angle13)**2)/$width, 0) x=(cos(2*$angle_elips13), sin(2*$angle_elips13), 0mm) y=(-sin(2*$angle_elips13), cos(2*$angle_elips13), 0mm)
  Box13 [NdFe38, oriented by RelativeCS13] = box(corner=(-$mag_bredth/2, -$mag_width/2, -$mag_length/2), size=($mag_bredth, $mag_width, $mag_length)) in RelativeCS13
  coordinate_system RelativeCS14 = origin=(-sqrt($width**2*sin($angle14)**2), $hieght*sqrt($width**2*cos($angle14)**2)/$width, 0) x=(cos(2*$angle_elips14), sin(2*$angle_elips14), 0mm) y=(-sin(2*$angle_elips14), cos(2*$angle_elips14), 0mm)
  Box14 [NdFe38, oriented by RelativeCS14] = box(corner=(-$mag_bredth/2, -$mag_width/2, -$mag_length/2), size=($mag_bredth, $mag_width, $mag_length)) in RelativeCS14
  coordinate_system RelativeCS15 = origin=(-sqrt($width**2*sin($angle15)**2), $hieght*sqrt($width**2*cos($angle15)**2)/$width, 0) x=(cos(2*$angle_elips15), sin(2*$angle_elips15), 0mm) y=(-sin(2*$angle_elips15), cos(2*$angle_elips15), 0mm)
  Box15 [NdFe38, oriented by RelativeCS15] = box(corner=(-$mag_bredth/2, -$mag_width/2, -$mag_length/2), size=($mag_bredth, $mag_width, $mag_length)) in RelativeCS15
  coordinate_system center = origin=(0mm, 0mm, (($num_of_rows-1)/2)*$length_between_row) x=(1mm, 0mm, 0mm) y=(0mm, 1mm, 0mm)
  sweet_spot_box [vacuum, non-model, oriented by center] = box(corner=(0, 0, -$swet_spot_length/2), size=($sweet_spot/2, $sweet_spot/2, $swet_spot_length)) in center
  Rectangle1 [non-model] = rectangle(corner=(-($r+$buffer), -($r+$buffer), -$mag_length/2), x_size=($r+$buffer)*2, y_size=($r+$buffer)*2)
  Rectangle1_1..Rectangle1_15 [non-model] = Rectangle1.duplicate_along_line(step=(0mm, 0mm, $length_between_sheet), total=16) in center
  Region [air] = region(percentage_offset=400 on all sides) in center
  point Point1 = (-110000mm, -90000mm, 0mm)
  Box0_1..Box0_4 [NdFe38, oriented by RelativeCS0] = Box0.duplicate_along_line(step=(0mm, 0mm, $length_between_row), total=5)
  Box1_1..Box1_4 [NdFe38, oriented by RelativeCS1] = Box1.duplicate_along_line(step=(0mm, 0mm, $length_between_row), total=5)
  Box2_1..Box2_4 [NdFe38, oriented by RelativeCS2] = Box2.duplicate_along_line(step=(0mm, 0mm, $length_between_row), total=5)
  Box3_1..Box3_4 [NdFe38, oriented by RelativeCS3] = Box3.duplicate_along_line(step=(0mm, 0mm, $length_between_row), total=5)
  Box4_1..Box4_4 [NdFe38, oriented by RelativeCS4] = Box4.duplicate_along_line(step=(0mm, 0mm, $length_between_row), total=5)
  Box5_1..Box5_4 [NdFe38, oriented by RelativeCS5] = Box5.duplicate_along_line(step=(0mm, 0mm, $length_between_row), total=5)
  Box6_1..Box6_4 [NdFe38, oriented by RelativeCS6] = Box6.duplicate_along_line(step=(0mm, 0mm, $length_between_row), total=5)
  Box7_1..Box7_4 [NdFe38, oriented by RelativeCS7] = Box7.duplicate_along_line(step=(0mm, 0mm, $length_between_row), total=5)
  Box8_1..Box8_4 [NdFe38, oriented by RelativeCS8] = Box8.duplicate_along_line(step=(0mm, 0mm, $length_between_row), total=5)
  Box9_1..Box9_4 [NdFe38, oriented by RelativeCS9] = Box9.duplicate_along_line(step=(0mm, 0mm, $length_between_row), total=5)
  Box10_1..Box10_4 [NdFe38, oriented by RelativeCS10] = Box10.duplicate_along_line(step=(0mm, 0mm, $length_between_row), total=5)
  Box11_1..Box11_4 [NdFe38, oriented by RelativeCS11] = Box11.duplicate_along_line(step=(0mm, 0mm, $length_between_row), total=5)
  Box12_1..Box12_4 [NdFe38, oriented by RelativeCS12] = Box12.duplicate_along_line(step=(0mm, 0mm, $length_between_row), total=5)
  Box13_1..Box13_4 [NdFe38, oriented by RelativeCS13] = Box13.duplicate_along_line(step=(0mm, 0mm, $length_between_row), total=5)
  Box14_1..Box14_4 [NdFe38, oriented by RelativeCS14] = Box14.duplicate_along_line(step=(0mm, 0mm, $length_between_row), total=5)
  Box15_1..Box15_4 [NdFe38, oriented by RelativeCS15] = Box15.duplicate_along_line(step=(0mm, 0mm, $length_between_row), total=5)
  group Box_Group = Box0..Box15, Box0_1..Box0_4, Box1_1..Box1_4, Box2_1..Box2_4, Box3_1..Box3_4, Box4_1..Box4_4, Box5_1..Box5_4, Box6_1..Box6_4, Box7_1..Box7_4, Box8_1..Box8_4, Box9_1..Box9_4, Box10_1..Box10_4, Box11_1..Box11_4, Box12_1..Box12_4, Box13_1..Box13_4, Box14_1..Box14_4, Box15_1..Box15_4
  group Rectangle_Group = Rectangle1, Rectangle1_1..Rectangle1_15
mesh:
  Length1: LengthBased Objects=[Box0..Box15] NumMaxElem=10000
  initial mesh: GlobalCurvilinear{Apply}
setups:
  Setup1: Magnetostatic MaximumPasses=5 MinimumPasses=2 MinimumConvergedPasses=1 PercentRefinement=30 PercentError=1 NonLinearResidual=0.001
optimetrics:
  ParametricSetup1: Parametric disabled Sim._Setups=[Setup1]
    sweep $move_r: LIN 20 25 1
    calculate mean_sweet_spot on Setup1 : LastAdaptive
    calculate diffrens on Setup1 : LastAdaptive
field calculator expressions:
  mean_sweet_spot = Mag_B | EnterVolume(sweet_spot_box) | VolumeValue | Mean
  diffrens = Mag_B | EnterVolume(sweet_spot_box) | VolumeValue | Maximum | Mag_B | EnterVolume(sweet_spot_box) | VolumeValue | Minimum | -
  differens_abs = diffrens | Abs
  net_X = Mag_B | VecX | ScalarX | EnterVolume(sweet_spot_box) | VolumeValue | Integrate
  sweet_spot_volume = 1 | EnterVolume(sweet_spot_box) | VolumeValue | Integrate
field plots:
  diffrens1: NamedExpr in sweet_spot_box on Setup1 : LastAdaptive
  H_Vector1: H in sweet_spot_box on Setup1 : LastAdaptive
  Mag_B1, Mag_B2, B_Vector2: B over a plane on Setup1 : LastAdaptive
  B_Vector1: B in sweet_spot_box on Setup1 : LastAdaptive
reports:
  Calculator Expressions Table 3: mean_sweet_spot vs $move_r on Setup1 : LastAdaptive
  Calculator Expressions Table 4: mean_sweet_spot, diffrens vs $move_r on Setup1 : LastAdaptive
