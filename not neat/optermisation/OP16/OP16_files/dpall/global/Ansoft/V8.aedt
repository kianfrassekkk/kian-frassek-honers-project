# Ansys Electronics Desktop project, version 2020.2
project variables:
  $swet_spot_length = 30mm
  $sweet_spot = 40mm
  $magnet_hight = 4mm
  $mag_length = 4mm
  $mag_width = 5mm
  $Angle_between = 2*pi/$num_of_magnets rad
  $position_x_touch = ($magnet_hight+(cos($angle1)*($mag_width+$magnet_hight)))/(2*sin($Angle_between))
  $position_y_touch = ($mag_width+(cos($angle1)*($mag_width+$magnet_hight)))/(2*sin($Angle_between))
  $position_sweetspot_touch = sqrt(2*sqr($sweet_spot/2))+sqrt(sqr($mag_width/2)+sqr($magnet_hight/2))
  $move_r = 20mm
  $r = max($position_y_touch,max($position_x_touch,$position_sweetspot_touch))+$move_r
  $num_of_magnets = 32
  $angle1 = ($Angle_between*1*2) rad
  $angle2 = ($Angle_between*2*2) rad
  $angle3 = ($Angle_between*3*2) rad
  $angle4 = ($Angle_between*4*2) rad
  $angle5 = ($Angle_between*5*2) rad
  $angle6 = ($Angle_between*6*2) rad
  $angle7 = ($Angle_between*7*2) rad
  $angle8 = ($Angle_between*8*2) rad
  $angle9 = ($Angle_between*9*2) rad
  $angle10 = ($Angle_between*10*2) rad
  $angle11 = ($Angle_between*11*2) rad
  $angle12 = ($Angle_between*12*2) rad
  $angle13 = ($Angle_between*13*2) rad
  $angle14 = ($Angle_between*14*2) rad
  $angle15 = ($Angle_between*15*2) rad
  $angle16 = $Angle_between*16*2
  $angle17 = $Angle_between*17*2
  $angle18 = $Angle_between*18*2
  $angle19 = $Angle_between*19*2
  $angle20 = $Angle_between*20*2
  $angle21 = $Angle_between*21*2
  $angle22 = $Angle_between*22*2
  $angle23 = $Angle_between*23*2
  $angle24 = $Angle_between*24*2
  $angle25 = $Angle_between*25*2
  $angle26 = $Angle_between*26*2
  $angle27 = $Angle_between*27*2
  $angle28 = $Angle_between*28*2
  $angle29 = $Angle_between*29*2
  $angle30 = $Angle_between*30*2
  $angle31 = $Angle_between*31*2
  $num_rows = 10
  $Disten_between_row = 0mm
materials:
  vacuum: permittivity=1
  NdFe30: permittivity=1 permeability=1.044573 conductivity=625000 magnetic_coercivity{Magnitude=-838000A_per_meter DirComp1=1 DirComp2=0 DirComp3=0} lande_g_factor=2
  air: permittivity=1.0006 permeability=1.0000004
  NdFe31: permittivity=1 permeability=1.044573 conductivity=625000 magnetic_coercivity{Magnitude=923000A_per_meter DirComp1=1 DirComp2=0 DirComp3=0} lande_g_factor=2
  NdFe42: permittivity=1 permeability=1.044573 conductivity=625000 magnetic_coercivity{Magnitude=-923000A_per_meter DirComp1=1 DirComp2=0 DirComp3=0} lande_g_factor=2
  NdFe35: permittivity=1 permeability=1.0997785 conductivity=625000 magnetic_coercivity{Magnitude=-890000A_per_meter DirComp1=1 DirComp2=0 DirComp3=0} lande_g_factor=2

design Maxwell3DDesign1 (Maxwell 3D, Magnetostatic, model units mm)
geometry:
  coordinate_system RelativeCS0 = origin=((($r*cos($Angle_between*0))*1609344)*6.2137119223733397e-07, (($r*sin($Angle_between*0))*1609344)*6.2137119223733397e-07, 0mm) x=(cos(0) mm, sin(0) mm, 0mm) y=(-sin(0) mm, cos(0) mm, 0mm)
  Box0 = box(corner=(((-$mag_length/2)*1609344)*6.2137119223733397e-07, ((-$magnet_hight/2)*1609344)*6.2137119223733397e-07, ((-$mag_width/2)*1609344)*6.2137119223733397e-07), size=((($mag_length)*1609344)*6.2137119223733397e-07, (($magnet_hight)*1609344)*6.2137119223733397e-07, (($mag_width)*1609344)*6.2137119223733397e-07)) in RelativeCS0
  coordinate_system RelativeCS1 = origin=((($r*cos($Angle_between*1))*1609344)*6.2137119223733397e-07, (($r*sin($Angle_between*1))*1609344)*6.2137119223733397e-07, 0mm) x=(((cos($angle1))*1609344)*6.2137119223733397e-07, ((sin($angle1))*1609344)*6.2137119223733397e-07, 0mm) y=(((-sin($angle1))*1609344)*6.2137119223733397e-07, ((cos($angle1))*1609344)*6.2137119223733397e-07, 0mm)
  coordinate_system RelativeCS2 = origin=((($r*cos($Angle_between*2))*1609344)*6.2137119223733397e-07, (($r*sin($Angle_between*2))*1609344)*6.2137119223733397e-07, 0mm) x=(((cos($angle2))*1609344)*6.2137119223733397e-07, ((sin($angle2))*1609344)*6.2137119223733397e-07, 0mm) y=(((-sin($angle2))*1609344)*6.2137119223733397e-07, ((cos($angle2))*1609344)*6.2137119223733397e-07, 0mm)
  coordinate_system RelativeCS3 = origin=((($r*cos($Angle_between*3))*1609344)*6.2137119223733397e-07, (($r*sin($Angle_between*3))*1609344)*6.2137119223733397e-07, 0mm) x=(((cos($angle3))*1609344)*6.2137119223733397e-07, ((sin($angle3))*1609344)*6.2137119223733397e-07, 0mm) y=(((-sin($angle3))*1609344)*6.2137119223733397e-07, ((cos($angle3))*1609344)*6.2137119223733397e-07, 0mm)
  coordinate_system RelativeCS4 = origin=((($r*cos($Angle_between*4))*1609344)*6.2137119223733397e-07, (($r*sin($Angle_between*4))*1609344)*6.2137119223733397e-07, 0mm) x=(((cos($angle4))*1609344)*6.2137119223733397e-07, ((sin($angle4))*1609344)*6.2137119223733397e-07, 0mm) y=(((-sin($angle4))*1609344)*6.2137119223733397e-07, ((cos($angle4))*1609344)*6.2137119223733397e-07, 0mm)
  coordinate_system RelativeCS5 = origin=((($r*cos($Angle_between*5))*1609344)*6.2137119223733397e-07, (($r*sin($Angle_between*5))*1609344)*6.2137119223733397e-07, 0mm) x=(((cos($angle5))*1609344)*6.2137119223733397e-07, ((sin($angle5))*1609344)*6.2137119223733397e-07, 0mm) y=(((-sin($angle4))*1609344)*6.2137119223733397e-07, ((cos($angle4))*1609344)*6.2137119223733397e-07, 0mm)
  coordinate_system RelativeCS6 = origin=((($r*cos($Angle_between*6))*1609344)*6.2137119223733397e-07, (($r*sin($Angle_between*6))*1609344)*6.2137119223733397e-07, 0mm) x=(((cos($angle6))*1609344)*6.2137119223733397e-07, ((sin($angle6))*1609344)*6.2137119223733397e-07, 0mm) y=(((-sin($angle6))*1609344)*6.2137119223733397e-07, ((cos($angle6))*1609344)*6.2137119223733397e-07, 0mm)
  coordinate_system RelativeCS7 = origin=((($r*cos($Angle_between*7))*1609344)*6.2137119223733397e-07, (($r*sin($Angle_between*7))*1609344)*6.2137119223733397e-07, 0mm) x=(((cos($angle7))*1609344)*6.2137119223733397e-07, ((sin($angle7))*1609344)*6.2137119223733397e-07, 0mm) y=(((-sin($angle7))*1609344)*6.2137119223733397e-07, ((cos($angle7))*1609344)*6.2137119223733397e-07, 0mm)
  coordinate_system RelativeCS8 = origin=((($r*cos($Angle_between*8))*1609344)*6.2137119223733397e-07, (($r*sin($Angle_between*8))*1609344)*6.2137119223733397e-07, 0mm) x=(((cos($angle8))*1609344)*6.2137119223733397e-07, ((sin($angle8))*1609344)*6.2137119223733397e-07, 0mm) y=(((-sin($angle8))*1609344)*6.2137119223733397e-07, ((cos($angle8))*1609344)*6.2137119223733397e-07, 0mm)
  coordinate_system RelativeCS9 = origin=((($r*cos($Angle_between*9))*1609344)*6.2137119223733397e-07, (($r*sin($Angle_between*9))*1609344)*6.2137119223733397e-07, 0mm) x=(((cos($angle9))*1609344)*6.2137119223733397e-07, ((sin($angle9))*1609344)*6.2137119223733397e-07, 0mm) y=(((-sin($angle9))*1609344)*6.2137119223733397e-07, ((cos($angle9))*1609344)*6.2137119223733397e-07, 0mm)
  coordinate_system RelativeCS10 = origin=((($r*cos($Angle_between*10))*1609344)*6.2137119223733397e-07, (($r*sin($Angle_between*10))*1609344)*6.2137119223733397e-07, 0mm) x=(((cos($angle10))*1609344)*6.2137119223733397e-07, ((sin($angle10))*1609344)*6.2137119223733397e-07, 0mm) y=(((-sin($angle10))*1609344)*6.2137119223733397e-07, ((cos($angle10))*1609344)*6.2137119223733397e-07, 0mm)
  coordinate_system RelativeCS11 = origin=((($r*cos($Angle_between*11))*1609344)*6.2137119223733397e-07, (($r*sin($Angle_between*11))*1609344)*6.2137119223733397e-07, 0mm) x=(((cos($angle11))*1609344)*6.2137119223733397e-07, ((sin($angle11))*1609344)*6.2137119223733397e-07, 0mm) y=(((-sin($angle11))*1609344)*6.2137119223733397e-07, ((cos($angle11))*1609344)*6.2137119223733397e-07, 0mm)
  coordinate_system RelativeCS12 = origin=((($r*cos($Angle_between*12))*1609344)*6.2137119223733397e-07, (($r*sin($Angle_between*12))*1609344)*6.2137119223733397e-07, 0mm) x=(((cos($angle12))*1609344)*6.2137119223733397e-07, ((sin($angle12))*1609344)*6.2137119223733397e-07, 0mm) y=(((-sin($angle12))*1609344)*6.2137119223733397e-07, ((cos($angle12))*1609344)*6.2137119223733397e-07, 0mm)
  coordinate_system RelativeCS13 = origin=((($r*cos($Angle_between*13))*1609344)*6.2137119223733397e-07, (($r*sin($Angle_between*13))*1609344)*6.2137119223733397e-07, 0mm) x=(((cos($angle13))*1609344)*6.2137119223733397e-07, ((sin($angle13))*1609344)*6.2137119223733397e-07, 0mm) y=(((-sin($angle13))*1609344)*6.2137119223733397e-07, ((cos($angle13))*1609344)*6.2137119223733397e-07, 0mm)
  coordinate_system RelativeCS14 = origin=((($r*cos($Angle_between*14))*1609344)*6.2137119223733397e-07, (($r*sin($Angle_between*14))*1609344)*6.2137119223733397e-07, 0mm) x=(((cos($angle14))*1609344)*6.2137119223733397e-07, ((sin($angle14))*1609344)*6.2137119223733397e-07, 0mm) y=(((-sin($angle14))*1609344)*6.2137119223733397e-07, ((cos($angle14))*1609344)*6.2137119223733397e-07, 0mm)
  coordinate_system RelativeCS15 = origin=((($r*cos($Angle_between*15))*1609344)*6.2137119223733397e-07, (($r*sin($Angle_between*15))*1609344)*6.2137119223733397e-07, 0mm) x=(((cos($angle15))*1609344)*6.2137119223733397e-07, ((sin($angle15))*1609344)*6.2137119223733397e-07, 0mm) y=(((-sin($angle15))*1609344)*6.2137119223733397e-07, ((cos($angle15))*1609344)*6.2137119223733397e-07, 0mm)
  coordinate_system RelativeCS16 = origin=((($r*cos($Angle_between*16))*1609344)*6.2137119223733397e-07, (($r*sin($Angle_between*16))*1609344)*6.2137119223733397e-07, 0mm) x=(((cos($angle16))*1609344)*6.2137119223733397e-07, ((sin($angle16))*1609344)*6.2137119223733397e-07, 0mm) y=(((-sin($angle16))*1609344)*6.2137119223733397e-07, ((cos($angle16))*1609344)*6.2137119223733397e-07, 0mm)
  coordinate_system RelativeCS17 = origin=((($r*cos($Angle_between*17))*1609344)*6.2137119223733397e-07, (($r*sin($Angle_between*17))*1609344)*6.2137119223733397e-07, 0mm) x=(((cos($angle17))*1609344)*6.2137119223733397e-07, ((sin($angle17))*1609344)*6.2137119223733397e-07, 0mm) y=(((-sin($angle17))*1609344)*6.2137119223733397e-07, ((cos($angle17))*1609344)*6.2137119223733397e-07, 0mm)
  coordinate_system RelativeCS18 = origin=((($r*cos($Angle_between*18))*1609344)*6.2137119223733397e-07, (($r*sin($Angle_between*18))*1609344)*6.2137119223733397e-07, 0mm) x=(((cos($angle18))*1609344)*6.2137119223733397e-07, ((sin($angle18))*1609344)*6.2137119223733397e-07, 0mm) y=(((-sin($angle18))*1609344)*6.2137119223733397e-07, ((cos($angle18))*1609344)*6.2137119223733397e-07, 0mm)
  coordinate_system RelativeCS19 = origin=((($r*cos($Angle_between*19))*1609344)*6.2137119223733397e-07, (($r*sin($Angle_between*19))*1609344)*6.2137119223733397e-07, 0mm) x=(((cos($angle19))*1609344)*6.2137119223733397e-07, ((sin($angle19))*1609344)*6.2137119223733397e-07, 0mm) y=(((-sin($angle19))*1609344)*6.2137119223733397e-07, ((cos($angle19))*1609344)*6.2137119223733397e-07, 0mm)
  coordinate_system RelativeCS20 = origin=((($r*cos($Angle_between*20))*1609344)*6.2137119223733397e-07, (($r*sin($Angle_between*20))*1609344)*6.2137119223733397e-07, 0mm) x=(((cos($angle20))*1609344)*6.2137119223733397e-07, ((sin($angle20))*1609344)*6.2137119223733397e-07, 0mm) y=(((-sin($angle20))*1609344)*6.2137119223733397e-07, ((cos($angle20))*1609344)*6.2137119223733397e-07, 0mm)
  coordinate_system RelativeCS21 = origin=((($r*cos($Angle_between*21))*1609344)*6.2137119223733397e-07, (($r*sin($Angle_between*21))*1609344)*6.2137119223733397e-07, 0mm) x=(((cos($angle21))*1609344)*6.2137119223733397e-07, ((sin($angle21))*1609344)*6.2137119223733397e-07, 0mm) y=(((-sin($angle21))*1609344)*6.2137119223733397e-07, ((cos($angle21))*1609344)*6.2137119223733397e-07, 0mm)
  coordinate_system RelativeCS22 = origin=((($r*cos($Angle_between*22))*1609344)*6.2137119223733397e-07, (($r*sin($Angle_between*22))*1609344)*6.2137119223733397e-07, 0mm) x=(((cos($angle22))*1609344)*6.2137119223733397e-07, ((sin($angle22))*1609344)*6.2137119223733397e-07, 0mm) y=(((-sin($angle22))*1609344)*6.2137119223733397e-07, ((cos($angle22))*1609344)*6.2137119223733397e-07, 0mm)
  coordinate_system RelativeCS23 = origin=((($r*cos($Angle_between*23))*1609344)*6.2137119223733397e-07, (($r*sin($Angle_between*23))*1609344)*6.2137119223733397e-07, 0mm) x=(((cos($angle23))*1609344)*6.2137119223733397e-07, ((sin($angle23))*1609344)*6.2137119223733397e-07, 0mm) y=(((-sin($angle23))*1609344)*6.2137119223733397e-07, ((cos($angle23))*1609344)*6.2137119223733397e-07, 0mm)
  coordinate_system RelativeCS24 = origin=((($r*cos($Angle_between*24))*1609344)*6.2137119223733397e-07, (($r*sin($Angle_between*24))*1609344)*6.2137119223733397e-07, 0mm) x=(((cos($angle24))*1609344)*6.2137119223733397e-07, ((sin($angle24))*1609344)*6.2137119223733397e-07, 0mm) y=(((-sin($angle24))*1609344)*6.2137119223733397e-07, ((cos($angle24))*1609344)*6.2137119223733397e-07, 0mm)
  coordinate_system RelativeCS25 = origin=((($r*cos($Angle_between*25))*1609344)*6.2137119223733397e-07, (($r*sin($Angle_between*25))*1609344)*6.2137119223733397e-07, 0mm) x=(((cos($angle25))*1609344)*6.2137119223733397e-07, ((sin($angle25))*1609344)*6.2137119223733397e-07, 0mm) y=(((-sin($angle25))*1609344)*6.2137119223733397e-07, ((cos($angle25))*1609344)*6.2137119223733397e-07, 0mm)
  coordinate_system RelativeCS26 = origin=((($r*cos($Angle_between*26))*1609344)*6.2137119223733397e-07, (($r*sin($Angle_between*26))*1609344)*6.2137119223733397e-07, 0mm) x=(((cos($angle26))*1609344)*6.2137119223733397e-07, ((sin($angle26))*1609344)*6.2137119223733397e-07, 0mm) y=(((-sin($angle26))*1609344)*6.2137119223733397e-07, ((cos($angle26))*1609344)*6.2137119223733397e-07, 0mm)
  coordinate_system RelativeCS27 = origin=((($r*cos($Angle_between*27))*1609344)*6.2137119223733397e-07, (($r*sin($Angle_between*27))*1609344)*6.2137119223733397e-07, 0mm) x=(((cos($angle27))*1609344)*6.2137119223733397e-07, ((sin($angle27))*1609344)*6.2137119223733397e-07, 0mm) y=(((-sin($angle27))*1609344)*6.2137119223733397e-07, ((cos($angle27))*1609344)*6.2137119223733397e-07, 0mm)
  coordinate_system RelativeCS28 = origin=((($r*cos($Angle_between*28))*1609344)*6.2137119223733397e-07, (($r*sin($Angle_between*28))*1609344)*6.2137119223733397e-07, 0mm) x=(((cos($angle28))*1609344)*6.2137119223733397e-07, ((sin($angle28))*1609344)*6.2137119223733397e-07, 0mm) y=(((-sin($angle28))*1609344)*6.2137119223733397e-07, ((cos($angle28))*1609344)*6.2137119223733397e-07, 0mm)
  coordinate_system RelativeCS29 = origin=((($r*cos($Angle_between*29))*1609344)*6.2137119223733397e-07, (($r*sin($Angle_between*29))*1609344)*6.2137119223733397e-07, 0mm) x=(((cos($angle29))*1609344)*6.2137119223733397e-07, ((sin($angle29))*1609344)*6.2137119223733397e-07, 0mm) y=(((-sin($angle29))*1609344)*6.2137119223733397e-07, ((cos($angle29))*1609344)*6.2137119223733397e-07, 0mm)
  coordinate_system RelativeCS30 = origin=((($r*cos($Angle_between*30))*1609344)*6.2137119223733397e-07, (($r*sin($Angle_between*30))*1609344)*6.2137119223733397e-07, 0mm) x=(((cos($angle30))*1609344)*6.2137119223733397e-07, ((sin($angle30))*1609344)*6.2137119223733397e-07, 0mm) y=(((-sin($angle30))*1609344)*6.2137119223733397e-07, ((cos($angle30))*1609344)*6.2137119223733397e-07, 0mm)
  coordinate_system RelativeCS31 = origin=((($r*cos($Angle_between*31))*1609344)*6.2137119223733397e-07, (($r*sin($Angle_between*31))*1609344)*6.2137119223733397e-07, 0mm) x=(((cos($angle31))*1609344)*6.2137119223733397e-07, ((sin($angle31))*1609344)*6.2137119223733397e-07, 0mm) y=(((-sin($angle31))*1609344)*6.2137119223733397e-07, ((cos($angle31))*1609344)*6.2137119223733397e-07, 0mm)
  Box01 = box(corner=(((-$mag_length/2)*1609344)*6.2137119223733397e-07, ((-$magnet_hight/2)*1609344)*6.2137119223733397e-07, ((-$mag_width/2)*1609344)*6.2137119223733397e-07), size=((($mag_length)*1609344)*6.2137119223733397e-07, (($magnet_hight)*1609344)*6.2137119223733397e-07, (($mag_width)*1609344)*6.2137119223733397e-07)) in RelativeCS1
  Box02 = box(corner=(((-$mag_length/2)*1609344)*6.2137119223733397e-07, ((-$magnet_hight/2)*1609344)*6.2137119223733397e-07, ((-$mag_width/2)*1609344)*6.2137119223733397e-07), size=((($mag_length)*1609344)*6.2137119223733397e-07, (($magnet_hight)*1609344)*6.2137119223733397e-07, (($mag_width)*1609344)*6.2137119223733397e-07)) in RelativeCS2
  Box03 = box(corner=(((-$mag_length/2)*1609344)*6.2137119223733397e-07, ((-$magnet_hight/2)*1609344)*6.2137119223733397e-07, ((-$mag_width/2)*1609344)*6.2137119223733397e-07), size=((($mag_length)*1609344)*6.2137119223733397e-07, (($magnet_hight)*1609344)*6.2137119223733397e-07, (($mag_width)*1609344)*6.2137119223733397e-07)) in RelativeCS3
  Box04 = box(corner=(((-$mag_length/2)*1609344)*6.2137119223733397e-07, ((-$magnet_hight/2)*1609344)*6.2137119223733397e-07, ((-$mag_width/2)*1609344)*6.2137119223733397e-07), size=((($mag_length)*1609344)*6.2137119223733397e-07, (($magnet_hight)*1609344)*6.2137119223733397e-07, (($mag_width)*1609344)*6.2137119223733397e-07)) in RelativeCS4
  Box05 = box(corner=(((-$mag_length/2)*1609344)*6.2137119223733397e-07, ((-$magnet_hight/2)*1609344)*6.2137119223733397e-07, ((-$mag_width/2)*1609344)*6.2137119223733397e-07), size=((($mag_length)*1609344)*6.2137119223733397e-07, (($magnet_hight)*1609344)*6.2137119223733397e-07, (($mag_width)*1609344)*6.2137119223733397e-07)) in RelativeCS5
  Box06 = box(corner=(((-$mag_length/2)*1609344)*6.2137119223733397e-07, ((-$magnet_hight/2)*1609344)*6.2137119223733397e-07, ((-$mag_width/2)*1609344)*6.2137119223733397e-07), size=((($mag_length)*1609344)*6.2137119223733397e-07, (($magnet_hight)*1609344)*6.2137119223733397e-07, (($mag_width)*1609344)*6.2137119223733397e-07)) in RelativeCS6
  Box07 = box(corner=(((-$mag_length/2)*1609344)*6.2137119223733397e-07, ((-$magnet_hight/2)*1609344)*6.2137119223733397e-07, ((-$mag_width/2)*1609344)*6.2137119223733397e-07), size=((($mag_length)*1609344)*6.2137119223733397e-07, (($magnet_hight)*1609344)*6.2137119223733397e-07, (($mag_width)*1609344)*6.2137119223733397e-07)) in RelativeCS7
  Box08 = box(corner=(((-$mag_length/2)*1609344)*6.2137119223733397e-07, ((-$magnet_hight/2)*1609344)*6.2137119223733397e-07, ((-$mag_width/2)*1609344)*6.2137119223733397e-07), size=((($mag_length)*1609344)*6.2137119223733397e-07, (($magnet_hight)*1609344)*6.2137119223733397e-07, (($mag_width)*1609344)*6.2137119223733397e-07)) in RelativeCS8
  Box09 = box(corner=(((-$mag_length/2)*1609344)*6.2137119223733397e-07, ((-$magnet_hight/2)*1609344)*6.2137119223733397e-07, ((-$mag_width/2)*1609344)*6.2137119223733397e-07), size=((($mag_length)*1609344)*6.2137119223733397e-07, (($magnet_hight)*1609344)*6.2137119223733397e-07, (($mag_width)*1609344)*6.2137119223733397e-07)) in RelativeCS9
  Box010 = box(corner=(((-$mag_length/2)*1609344)*6.2137119223733397e-07, ((-$magnet_hight/2)*1609344)*6.2137119223733397e-07, ((-$mag_width/2)*1609344)*6.2137119223733397e-07), size=((($mag_length)*1609344)*6.2137119223733397e-07, (($magnet_hight)*1609344)*6.2137119223733397e-07, (($mag_width)*1609344)*6.2137119223733397e-07)) in RelativeCS10
  Box011 = box(corner=(((-$mag_length/2)*1609344)*6.2137119223733397e-07, ((-$magnet_hight/2)*1609344)*6.2137119223733397e-07, ((-$mag_width/2)*1609344)*6.2137119223733397e-07), size=((($mag_length)*1609344)*6.2137119223733397e-07, (($magnet_hight)*1609344)*6.2137119223733397e-07, (($mag_width)*1609344)*6.2137119223733397e-07)) in RelativeCS11
  Box012 = box(corner=(((-$mag_length/2)*1609344)*6.2137119223733397e-07, ((-$magnet_hight/2)*1609344)*6.2137119223733397e-07, ((-$mag_width/2)*1609344)*6.2137119223733397e-07), size=((($mag_length)*1609344)*6.2137119223733397e-07, (($magnet_hight)*1609344)*6.2137119223733397e-07, (($mag_width)*1609344)*6.2137119223733397e-07)) in RelativeCS12
  Box013 = box(corner=(((-$mag_length/2)*1609344)*6.2137119223733397e-07, ((-$magnet_hight/2)*1609344)*6.2137119223733397e-07, ((-$mag_width/2)*1609344)*6.2137119223733397e-07), size=((($mag_length)*1609344)*6.2137119223733397e-07, (($magnet_hight)*1609344)*6.2137119223733397e-07, (($mag_width)*1609344)*6.2137119223733397e-07)) in RelativeCS13
  Box014 = box(corner=(((-$mag_length/2)*1609344)*6.2137119223733397e-07, ((-$magnet_hight/2)*1609344)*6.2137119223733397e-07, ((-$mag_width/2)*1609344)*6.2137119223733397e-07), size=((($mag_length)*1609344)*6.2137119223733397e-07, (($magnet_hight)*1609344)*6.2137119223733397e-07, (($mag_width)*1609344)*6.2137119223733397e-07)) in RelativeCS14
  Box015 = box(corner=(((-$mag_length/2)*1609344)*6.2137119223733397e-07, ((-$magnet_hight/2)*1609344)*6.2137119223733397e-07, ((-$mag_width/2)*1609344)*6.2137119223733397e-07), size=((($mag_length)*1609344)*6.2137119223733397e-07, (($magnet_hight)*1609344)*6.2137119223733397e-07, (($mag_width)*1609344)*6.2137119223733397e-07)) in RelativeCS15
  Box016 = box(corner=(((-$mag_length/2)*1609344)*6.2137119223733397e-07, ((-$magnet_hight/2)*1609344)*6.2137119223733397e-07, ((-$mag_width/2)*1609344)*6.2137119223733397e-07), size=((($mag_length)*1609344)*6.2137119223733397e-07, (($magnet_hight)*1609344)*6.2137119223733397e-07, (($mag_width)*1609344)*6.2137119223733397e-07)) in RelativeCS16
  Box017 = box(corner=(((-$mag_length/2)*1609344)*6.2137119223733397e-07, ((-$magnet_hight/2)*1609344)*6.2137119223733397e-07, ((-$mag_width/2)*1609344)*6.2137119223733397e-07), size=((($mag_length)*1609344)*6.2137119223733397e-07, (($magnet_hight)*1609344)*6.2137119223733397e-07, (($mag_width)*1609344)*6.2137119223733397e-07)) in RelativeCS17
  Box018 = box(corner=(((-$mag_length/2)*1609344)*6.2137119223733397e-07, ((-$magnet_hight/2)*1609344)*6.2137119223733397e-07, ((-$mag_width/2)*1609344)*6.2137119223733397e-07), size=((($mag_length)*1609344)*6.2137119223733397e-07, (($magnet_hight)*1609344)*6.2137119223733397e-07, (($mag_width)*1609344)*6.2137119223733397e-07)) in RelativeCS18
  Box019 = box(corner=(((-$mag_length/2)*1609344)*6.2137119223733397e-07, ((-$magnet_hight/2)*1609344)*6.2137119223733397e-07, ((-$mag_width/2)*1609344)*6.2137119223733397e-07), size=((($mag_length)*1609344)*6.2137119223733397e-07, (($magnet_hight)*1609344)*6.2137119223733397e-07, (($mag_width)*1609344)*6.2137119223733397e-07)) in RelativeCS19
  Box020 = box(corner=(((-$mag_length/2)*1609344)*6.2137119223733397e-07, ((-$magnet_hight/2)*1609344)*6.2137119223733397e-07, ((-$mag_width/2)*1609344)*6.2137119223733397e-07), size=((($mag_length)*1609344)*6.2137119223733397e-07, (($magnet_hight)*1609344)*6.2137119223733397e-07, (($mag_width)*1609344)*6.2137119223733397e-07)) in RelativeCS20
  Box021 = box(corner=(((-$mag_length/2)*1609344)*6.2137119223733397e-07, ((-$magnet_hight/2)*1609344)*6.2137119223733397e-07, ((-$mag_width/2)*1609344)*6.2137119223733397e-07), size=((($mag_length)*1609344)*6.2137119223733397e-07, (($magnet_hight)*1609344)*6.2137119223733397e-07, (($mag_width)*1609344)*6.2137119223733397e-07)) in RelativeCS21
  Box022 = box(corner=(((-$mag_length/2)*1609344)*6.2137119223733397e-07, ((-$magnet_hight/2)*1609344)*6.2137119223733397e-07, ((-$mag_width/2)*1609344)*6.2137119223733397e-07), size=((($mag_length)*1609344)*6.2137119223733397e-07, (($magnet_hight)*1609344)*6.2137119223733397e-07, (($mag_width)*1609344)*6.2137119223733397e-07)) in RelativeCS22
  Box023 = box(corner=(((-$mag_length/2)*1609344)*6.2137119223733397e-07, ((-$magnet_hight/2)*1609344)*6.2137119223733397e-07, ((-$mag_width/2)*1609344)*6.2137119223733397e-07), size=((($mag_length)*1609344)*6.2137119223733397e-07, (($magnet_hight)*1609344)*6.2137119223733397e-07, (($mag_width)*1609344)*6.2137119223733397e-07)) in RelativeCS23
  Box024 = box(corner=(((-$mag_length/2)*1609344)*6.2137119223733397e-07, ((-$magnet_hight/2)*1609344)*6.2137119223733397e-07, ((-$mag_width/2)*1609344)*6.2137119223733397e-07), size=((($mag_length)*1609344)*6.2137119223733397e-07, (($magnet_hight)*1609344)*6.2137119223733397e-07, (($mag_width)*1609344)*6.2137119223733397e-07)) in RelativeCS24
  Box025 = box(corner=(((-$mag_length/2)*1609344)*6.2137119223733397e-07, ((-$magnet_hight/2)*1609344)*6.2137119223733397e-07, ((-$mag_width/2)*1609344)*6.2137119223733397e-07), size=((($mag_length)*1609344)*6.2137119223733397e-07, (($magnet_hight)*1609344)*6.2137119223733397e-07, (($mag_width)*1609344)*6.2137119223733397e-07)) in RelativeCS25
  Box026 = box(corner=(((-$mag_length/2)*1609344)*6.2137119223733397e-07, ((-$magnet_hight/2)*1609344)*6.2137119223733397e-07, ((-$mag_width/2)*1609344)*6.2137119223733397e-07), size=((($mag_length)*1609344)*6.2137119223733397e-07, (($magnet_hight)*1609344)*6.2137119223733397e-07, (($mag_width)*1609344)*6.2137119223733397e-07)) in RelativeCS26
  Box027 = box(corner=(((-$mag_length/2)*1609344)*6.2137119223733397e-07, ((-$magnet_hight/2)*1609344)*6.2137119223733397e-07, ((-$mag_width/2)*1609344)*6.2137119223733397e-07), size=((($mag_length)*1609344)*6.2137119223733397e-07, (($magnet_hight)*1609344)*6.2137119223733397e-07, (($mag_width)*1609344)*6.2137119223733397e-07)) in RelativeCS27
  Box028 = box(corner=(((-$mag_length/2)*1609344)*6.2137119223733397e-07, ((-$magnet_hight/2)*1609344)*6.2137119223733397e-07, ((-$mag_width/2)*1609344)*6.2137119223733397e-07), size=((($mag_length)*1609344)*6.2137119223733397e-07, (($magnet_hight)*1609344)*6.2137119223733397e-07, (($mag_width)*1609344)*6.2137119223733397e-07)) in RelativeCS28
  Box029 = box(corner=(((-$mag_length/2)*1609344)*6.2137119223733397e-07, ((-$magnet_hight/2)*1609344)*6.2137119223733397e-07, ((-$mag_width/2)*1609344)*6.2137119223733397e-07), size=((($mag_length)*1609344)*6.2137119223733397e-07, (($magnet_hight)*1609344)*6.2137119223733397e-07, (($mag_width)*1609344)*6.2137119223733397e-07)) in RelativeCS29
  Box030 = box(corner=(((-$mag_length/2)*1609344)*6.2137119223733397e-07, ((-$magnet_hight/2)*1609344)*6.2137119223733397e-07, ((-$mag_width/2)*1609344)*6.2137119223733397e-07), size=((($mag_length)*1609344)*6.2137119223733397e-07, (($magnet_hight)*1609344)*6.2137119223733397e-07, (($mag_width)*1609344)*6.2137119223733397e-07)) in RelativeCS30
  Box031 = box(corner=(((-$mag_length/2)*1609344)*6.2137119223733397e-07, ((-$magnet_hight/2)*1609344)*6.2137119223733397e-07, ((-$mag_width/2)*1609344)*6.2137119223733397e-07), size=((($mag_length)*1609344)*6.2137119223733397e-07, (($magnet_hight)*1609344)*6.2137119223733397e-07, (($mag_width)*1609344)*6.2137119223733397e-07)) in RelativeCS31
  Box0_1..Box0_10 [NdFe35, oriented by RelativeCS0] = Box0.duplicate_along_line(step=(0mm, 0mm, (($mag_width+$Disten_between_row)*1609344)*6.2137119223733397e-07), total=20)  # copies kept: 1..10
  Box0.delete()
  Box01_1..Box01_10 [NdFe35] = Box01.duplicate_along_line(step=(0mm, 0mm, (($mag_width+$Disten_between_row)*1609344)*6.2137119223733397e-07), total=20)  # copies kept: 1..10
  Box01.delete()
  Box02_1..Box02_10 [NdFe35] = Box02.duplicate_along_line(step=(0mm, 0mm, (($mag_width+$Disten_between_row)*1609344)*6.2137119223733397e-07), total=20)  # copies kept: 1..10
  Box02.delete()
  Box03_1..Box03_10 [NdFe35] = Box03.duplicate_along_line(step=(0mm, 0mm, (($mag_width+$Disten_between_row)*1609344)*6.2137119223733397e-07), total=20)  # copies kept: 1..10
  Box03.delete()
  Box04_1..Box04_10 [NdFe35] = Box04.duplicate_along_line(step=(0mm, 0mm, (($mag_width+$Disten_between_row)*1609344)*6.2137119223733397e-07), total=20)  # copies kept: 1..10
  Box04.delete()
  Box05_1..Box05_10 [NdFe35] = Box05.duplicate_along_line(step=(0mm, 0mm, (($mag_width+$Disten_between_row)*1609344)*6.2137119223733397e-07), total=20)  # copies kept: 1..10
  Box05.delete()
  Box06_1..Box06_10 [NdFe35] = Box06.duplicate_along_line(step=(0mm, 0mm, (($mag_width+$Disten_between_row)*1609344)*6.2137119223733397e-07), total=20)  # copies kept: 1..10
  Box06.delete()
  Box07_1..Box07_10 [NdFe35] = Box07.duplicate_along_line(step=(0mm, 0mm, (($mag_width+$Disten_between_row)*1609344)*6.2137119223733397e-07), total=20)  # copies kept: 1..10
  Box07.delete()
  Box08_1..Box08_10 [NdFe35] = Box08.duplicate_along_line(step=(0mm, 0mm, (($mag_width+$Disten_between_row)*1609344)*6.2137119223733397e-07), total=20)  # copies kept: 1..10
  Box08.delete()
  Box09_1..Box09_10 [NdFe35] = Box09.duplicate_along_line(step=(0mm, 0mm, (($mag_width+$Disten_between_row)*1609344)*6.2137119223733397e-07), total=20)  # copies kept: 1..10
  Box09.delete()
  Box010_1..Box010_10 [NdFe35] = Box010.duplicate_along_line(step=(0mm, 0mm, (($mag_width+$Disten_between_row)*1609344)*6.2137119223733397e-07), total=20)  # copies kept: 1..10
  Box010.delete()
  Box011_1..Box011_10 [NdFe35] = Box011.duplicate_along_line(step=(0mm, 0mm, (($mag_width+$Disten_between_row)*1609344)*6.2137119223733397e-07), total=20)  # copies kept: 1..10
  Box011.delete()
  Box012_1..Box012_10 [NdFe35] = Box012.duplicate_along_line(step=(0mm, 0mm, (($mag_width+$Disten_between_row)*1609344)*6.2137119223733397e-07), total=20)  # copies kept: 1..10
  Box012.delete()
  Box013_1..Box013_10 [NdFe35] = Box013.duplicate_along_line(step=(0mm, 0mm, (($mag_width+$Disten_between_row)*1609344)*6.2137119223733397e-07), total=20)  # copies kept: 1..10
  Box013.delete()
  Box014_1..Box014_10 [NdFe35] = Box014.duplicate_along_line(step=(0mm, 0mm, (($mag_width+$Disten_between_row)*1609344)*6.2137119223733397e-07), total=20)  # copies kept: 1..10
  Box014.delete()
  Box015_1..Box015_10 [NdFe35] = Box015.duplicate_along_line(step=(0mm, 0mm, (($mag_width+$Disten_between_row)*1609344)*6.2137119223733397e-07), total=20)  # copies kept: 1..10
  Box015.delete()
  Box016_1..Box016_10 [NdFe35] = Box016.duplicate_along_line(step=(0mm, 0mm, (($mag_width+$Disten_between_row)*1609344)*6.2137119223733397e-07), total=20)  # copies kept: 1..10
  Box016.delete()
  Box017_1..Box017_10 [NdFe35] = Box017.duplicate_along_line(step=(0mm, 0mm, (($mag_width+$Disten_between_row)*1609344)*6.2137119223733397e-07), total=20)  # copies kept: 1..10
  Box017.delete()
  Box018_1..Box018_10 [NdFe35] = Box018.duplicate_along_line(step=(0mm, 0mm, (($mag_width+$Disten_between_row)*1609344)*6.2137119223733397e-07), total=20)  # copies kept: 1..10
  Box018.delete()
  Box019_1..Box019_10 [NdFe35] = Box019.duplicate_along_line(step=(0mm, 0mm, (($mag_width+$Disten_between_row)*1609344)*6.2137119223733397e-07), total=20)  # copies kept: 1..10
  Box019.delete()
  Box020_1..Box020_10 [NdFe35] = Box020.duplicate_along_line(step=(0mm, 0mm, (($mag_width+$Disten_between_row)*1609344)*6.2137119223733397e-07), total=20)  # copies kept: 1..10
  Box020.delete()
  Box021_1..Box021_10 [NdFe35] = Box021.duplicate_along_line(step=(0mm, 0mm, (($mag_width+$Disten_between_row)*1609344)*6.2137119223733397e-07), total=20)  # copies kept: 1..10
  Box021.delete()
  Box022_1..Box022_10 [NdFe35] = Box022.duplicate_along_line(step=(0mm, 0mm, (($mag_width+$Disten_between_row)*1609344)*6.2137119223733397e-07), total=20)  # copies kept: 1..10
  Box022.delete()
  Box023_1..Box023_10 [NdFe35] = Box023.duplicate_along_line(step=(0mm, 0mm, (($mag_width+$Disten_between_row)*1609344)*6.2137119223733397e-07), total=20)  # copies kept: 1..10
  Box023.delete()
  Box024_1..Box024_10 [NdFe35] = Box024.duplicate_along_line(step=(0mm, 0mm, (($mag_width+$Disten_between_row)*1609344)*6.2137119223733397e-07), total=20)  # copies kept: 1..10
  Box024.delete()
  Box025_1..Box025_10 [NdFe35] = Box025.duplicate_along_line(step=(0mm, 0mm, (($mag_width+$Disten_between_row)*1609344)*6.2137119223733397e-07), total=20)  # copies kept: 1..10
  Box025.delete()
  Box026_1..Box026_10 [NdFe35] = Box026.duplicate_along_line(step=(0mm, 0mm, (($mag_width+$Disten_between_row)*1609344)*6.2137119223733397e-07), total=20)  # copies kept: 1..10
  Box026.delete()
  Box027_1..Box027_10 [NdFe35] = Box027.duplicate_along_line(step=(0mm, 0mm, (($mag_width+$Disten_between_row)*1609344)*6.2137119223733397e-07), total=20)  # copies kept: 1..10
  Box027.delete()
  Box028_1..Box028_10 [NdFe35] = Box028.duplicate_along_line(step=(0mm, 0mm, (($mag_width+$Disten_between_row)*1609344)*6.2137119223733397e-07), total=20)  # copies kept: 1..10
  Box028.delete()
  Box029_1..Box029_10 [NdFe35] = Box029.duplicate_along_line(step=(0mm, 0mm, (($mag_width+$Disten_between_row)*1609344)*6.2137119223733397e-07), total=20)  # copies kept: 1..10
  Box029.delete()
  Box030_1..Box030_10 [NdFe35] = Box030.duplicate_along_line(step=(0mm, 0mm, (($mag_width+$Disten_between_row)*1609344)*6.2137119223733397e-07), total=20)  # copies kept: 1..10
  Box030.delete()
  Box031_1..Box031_10 [NdFe35] = Box031.duplicate_along_line(step=(0mm, 0mm, (($mag_width+$Disten_between_row)*1609344)*6.2137119223733397e-07), total=20)  # copies kept: 1..10
  Box031.delete()
  coordinate_system center = origin=(0mm, 0mm, ((($mag_width+$Disten_between_row)*($num_rows/2))*1609344)*6.2137119223733397e-07) x=(1mm, 0mm, 0mm) y=(0mm, 1mm, 0mm)
  sweet_spot [vacuum, non-model] = box(corner=(-$sweet_spot/2, -$sweet_spot/2, -$swet_spot_length/2), size=($sweet_spot, $sweet_spot, $swet_spot_length)) in center
  Region [air] = region(percentage_offset=300 on all sides) in center
mesh:
  Length1: LengthBased Objects=[Box0_1..Box0_10, Box01_1..Box01_10, Box02_1..Box02_10, Box03_1..Box03_10, Box04_1..Box04_10, Box05_1..Box05_10, Box06_1..Box06_10, Box07_1..Box07_10, Box08_1..Box08_10, Box09_1..Box09_10, Box010_1..Box010_10, Box011_1..Box011_10, Box012_1..Box012_10, Box013_1..Box013_10, Box014_1..Box014_10, Box015_1..Box015_10, Box016_1..Box016_10, Box017_1..Box017_10, Box018_1..Box018_10, Box019_1..Box019_10, Box020_1..Box020_10, Box021_1..Box021_10, Box022_1..Box022_10, Box023_1..Box023_10, Box024_1..Box024_10, Box025_1..Box025_10, Box026_1..Box026_10, Box027_1..Box027_10, Box028_1..Box028_10, Box029_1..Box029_10, Box030_1..Box030_10, Box031_1..Box031_10] NumMaxElem=10000 MaxLength=1272.7922mm
  initial mesh: GlobalCurvilinear{Apply}
setups:
  Setup1: Magnetostatic MaximumPasses=10 MinimumPasses=2 MinimumConvergedPasses=1 PercentRefinement=30 PercentError=1 NonLinearResidual=0.001
optimetrics:
  DefaultDesignXplorerSetup: DesignExplorer Sim._Setups=[Setup1] CostFunctionName=Cost CostFuncNormType=L2
    sweep $magnet_hight: 4mm
    sweep $mag_length: 4mm
    sweep $move_r: 0mm
    sweep $Disten_between_row: 0mm
    table edits: del(4mm, 4mm, 0mm, 0mm) add(9.24mm, 6.92mm, 21.4mm, 2.875mm)
    calculate mean on Setup1 : LastAdaptive
    calculate ppmmin on Setup1 : LastAdaptive
    calculate ppmmax on Setup1 : LastAdaptive
field calculator expressions:
  mean = Mag_B | EnterVolume(sweet_spot) | VolumeValue | Mean
  min = Mag_B | EnterVolume(sweet_spot) | VolumeValue | Minimum
  max = Mag_B | EnterVolume(sweet_spot) | VolumeValue | Maximum
  diffmin = mean | min | - | Abs
  difmax = mean | max | - | Abs
  ppmmin = diffmin | mean | / | 1000000 | *
  ppmmax = difmax | mean | / | 1000000 | *
reports:
  Calculator Expressions Table 2: max, min, diff, mean vs $move_r on Setup1 : LastAdaptive
  Calculator Expressions Table 3: min vs $swet_spot_length on Setup1 : LastAdaptive [$move_r=all $Disten_between_row=all]
  Calculator Expressions Table 4: max, min, diff, mean vs $move_r on Setup1 : LastAdaptive [$Disten_between_row=all]
  Calculator Expressions Table 5: min, max vs $swet_spot_length on Setup1 : LastAdaptive [$move_r=all]
  Calculator Expressions Table 6: max, min, diff, mean vs $move_r on Setup1 : LastAdaptive
  Calculator Expressions Table 7: min, max, diff, mean vs $swet_spot_length on Setup1 : LastAdaptive
