# Ansys Electronics Desktop project, version 2020.2
project variables:
  $num_mag_in_ring = 16
  $mag_bredth = 20mm
  $mag_width = 10mm
  $mag_length = 10mm
  $ratio_mod = 1
  $ratio = (max($mag_bredth,$mag_width)/min($mag_bredth,$mag_width))*$ratio_mod
  $Angle_between = 2*pi/$num_mag_in_ring
  $angle1 = $Angle_between*1
  $angle2 = $Angle_between*2
  $angle3 = $Angle_between*3
  $angle4 = $Angle_between*4
  $angle5 = $Angle_between*5
  $angle6 = $Angle_between*6
  $angle7 = $Angle_between*7
  $angle8 = $Angle_between*8
  $angle9 = $Angle_between*9
  $angle10 = $Angle_between*10
  $angle11 = $Angle_between*11
  $angle12 = $Angle_between*12
  $angle13 = $Angle_between*13
  $angle14 = $Angle_between*14
  $angle15 = $Angle_between*15
  $hieght = $r
  $width = $hieght*$ratio
  $angle_elips1 = atan($width*sqrt($width**2*sin($angle1)**2)/($hieght*sqrt($width**2*cos($angle1)**2)))
  $angle_elips2 = atan($width*sqrt($width**2*sin($angle2)**2)/($hieght*sqrt($width**2*cos($angle2)**2)))
  $angle_elips3 = atan($width*sqrt($width**2*sin($angle3)**2)/($hieght*sqrt($width**2*cos($angle3)**2)))
  $angle_elips5 = atan($width*sqrt($width**2*sin($angle5)**2)/($hieght*sqrt($width**2*cos($angle5)**2)))
  $angle_elips6 = atan($width*sqrt($width**2*sin($angle6)**2)/($hieght*sqrt($width**2*cos($angle6)**2)))
  $angle_elips7 = atan($width*sqrt($width**2*sin($angle7)**2)/($hieght*sqrt($width**2*cos($angle7)**2)))
  $angle_elips9 = atan($width*sqrt($width**2*sin($angle9)**2)/($hieght*sqrt($width**2*cos($angle9)**2)))
  $angle_elips10 = atan($width*sqrt($width**2*sin($angle10)**2)/($hieght*sqrt($width**2*cos($angle10)**2)))
  $angle_elips11 = atan($width*sqrt($width**2*sin($angle11)**2)/($hieght*sqrt($width**2*cos($angle11)**2)))
  $angle_elips13 = atan($width*sqrt($width**2*sin($angle13)**2)/($hieght*sqrt($width**2*cos($angle13)**2)))
  $angle_elips14 = atan($width*sqrt($width**2*sin($angle14)**2)/($hieght*sqrt($width**2*cos($angle14)**2)))
  $angle_elips15 = atan($width*sqrt($width**2*sin($angle15)**2)/($hieght*sqrt($width**2*cos($angle15)**2)))
  $position_sweetspot_touch = sqrt(2*sqr($sweet_spot/2))+sqrt(sqr($mag_width/2)+sqr($mag_bredth/2))
  $length_between_row = 11mm
  $swet_spot_length = 30mm
  $sweet_spot = 40mm
  $move_r = 0mm
  $num_of_sheets = 15
  $num_of_rows = 5
  $buffer = 10mm
  $length_between_sheet = ((($num_of_rows-1)*$length_between_row)+$mag_length)/$num_of_sheets
  $r = (max($close_fix,max($position_y_touch,max($position_x_touch,$clos_2)))+$move_r)
  $position_y_touch = ($mag_width+(cos($angle1)*($mag_width+$mag_bredth)))/(2*sin($Angle_between))
  $position_x_touch = ($mag_bredth+(cos($angle1)*($mag_width+$mag_bredth)))/(2*sin($Angle_between))
  $clos_radias = sqrt($mag_width+$mag_bredth)/(2+2*cos(0.39269908))
  $close_fix = $clos_radias
  $sweet_spot_fix = $position_sweetspot_touch
  $thing = max(1/($ratio*$Angle_between),$ratio*$Angle_between)
  $clos_2 = ($clos_radias+100) mm
materials:
  vacuum: permittivity=1
  NdFe30: permittivity=1 permeability=1.044573 conductivity=625000 magnetic_coercivity{Magnitude=-838000A_per_meter DirComp1=1 DirComp2=0 DirComp3=0} lande_g_factor=2
  air: permittivity=1.0006 permeability=1.0000004
  NdFe38: permittivity=1 permeability=1.0997785 conductivity=625000 magnetic_coercivity{Magnitude=-899000A_per_meter DirComp1=1 DirComp2=0 DirComp3=0} lande_g_factor=2

design Maxwell3DDesign1 (Maxwell 3D, Magnetostatic, model units mm)
geometry:
  coordinate_system RelativeCS0 = origin=(0, $hieght, 0) x=(cos(0) mm, sin(0) mm, 0mm) y=(-sin(0) mm, cos(0) mm, 0mm)
  Box0 [NdFe38, oriented by RelativeCS0] = box(corner=(-$mag_bredth/2, -$mag_width/2, -$mag_length/2), size=($mag_bredth, $mag_width, $mag_length)) in RelativeCS0
  coordinate_system RelativeCS1 = origin=(sqrt($width**2*sin($angle1)**2), $hieght*sqrt($width**2*cos($angle1)**2)/$width, 0) x=(cos(2*$angle_elips1), -sin(2*$angle_elips1), 0mm) y=(sin(2*$angle_elips1), cos(2*$angle_elips1), 0mm)
  Box1 [NdFe38, oriented by RelativeCS1] = box(corner=(-$mag_bredth/2, -$mag_width/2, -$mag_length/2), size=($mag_bredth, $mag_width, $mag_length)) in RelativeCS1
  coordinate_system RelativeCS2 = origin=(sqrt($width**2*sin($angle2)**2), $hieght*sqrt($width**2*cos($angle2)**2)/$width, 0) x=(cos(2*$angle_elips2), -sin(2*$angle_elips2), 0mm) y=(sin(2*$angle_elips2), cos(2*$angle_elips2), 0mm)
  Box2 [NdFe38, oriented by RelativeCS2] = box(corner=(-$mag_bredth/2, -$mag_width/2, -$mag_length/2), size=($mag_bredth, $mag_width, $mag_length)) in RelativeCS2
  coordinate_system RelativeCS3 = origin=(sqrt($width**2*sin($angle3)**2), $hieght*sqrt($width**2*cos($angle3)**2)/$width, 0) x=(cos(2*$angle_elips3), -sin(2*$angle_elips3), 0mm) y=(sin(2*$angle_elips3), cos(2*$angle_elips3), 0mm)
  Box3 [NdFe38, oriented by RelativeCS3] = box(corner=(-$mag_bredth/2, -$mag_width/2, -$mag_length/2), size=($mag_bredth, $mag_width, $mag_length)) in RelativeCS3
  coordinate_system RelativeCS4 = origin=($width, 0, 0mm) x=(cos(2*$angle4), sin(2*$angle4), 0mm) y=(-sin(2*$angle4), cos(2*$angle4), 0mm)
  Box4 [NdFe38, oriented by RelativeCS4] = box(corner=(-$mag_bredth/2, -$mag_width/2, -$mag_length/2), size=($mag_bredth, $mag_width, $mag_length)) in RelativeCS4
  coordinate_system RelativeCS5 = origin=(sqrt($width**2*sin($angle5)**2), -$hieght*sqrt($width**2*cos($angle5)**2)/$width, 0) x=(cos(2*$angle_elips5), sin(2*$angle_elips5), 0mm) y=(-sin(2*$angle_elips5), cos(2*$angle_elips5), 0mm)
  Box5 [NdFe38, oriented by RelativeCS5] = box(corner=(-$mag_bredth/2, -$mag_width/2, -$mag_length/2), size=($mag_bredth, $mag_width, $mag_length)) in RelativeCS5
  coordinate_system RelativeCS6 = origin=(sqrt($width**2*sin($angle6)**2), -$hieght*sqrt($width**2*cos($angle6)**2)/$width, 0) x=(cos(2*$angle_elips6), sin(2*$angle_elips6), 0mm) y=(-sin(2*$angle_elips6), cos(2*$angle_elips6), 0mm)
  Box6 [NdFe38, oriented by RelativeCS6] = box(corner=(-$mag_bredth/2, -$mag_width/2, -$mag_length/2), size=($mag_bredth, $mag_width, $mag_length)) in RelativeCS6
  coordinate_system RelativeCS7 = origin=(sqrt($width**2*sin($angle7)**2), -$hieght*sqrt($width**2*cos($angle7)**2)/$width, 0) x=(cos(2*$angle_elips7), sin(2*$angle_elips7), 0mm) y=(-sin(2*$angle_elips7), cos(2*$angle_elips7), 0mm)
  Box7 [NdFe38, oriented by RelativeCS7] = box(corner=(-$mag_bredth/2, -$mag_width/2, -$mag_length/2), size=($mag_bredth, $mag_width, $mag_length)) in RelativeCS7
  coordinate_system RelativeCS8 = origin=(0, -$hieght, 0) x=(cos(2*$angle8), -sin(2*$angle8), 0mm) y=(sin(2*$angle8), cos(2*$angle8), 0mm)
  Box8 [NdFe38, oriented by RelativeCS8] = box(corner=(-$mag_bredth/2, -$mag_width/2, -$mag_length/2), size=($mag_bredth, $mag_width, $mag_length)) in RelativeCS8
  coordinate_system RelativeCS9 = origin=(-sqrt($width**2*sin($angle9)**2), -$hieght*sqrt($width**2*cos($angle9)**2)/$width, 0) x=(cos(2*$angle_elips9), -sin(2*$angle_elips9), 0mm) y=(sin(2*$angle_elips9), cos(2*$angle_elips9), 0mm)
  Box9 [NdFe38, oriented by RelativeCS9] = box(corner=(-$mag_bredth/2, -$mag_width/2, -$mag_length/2), size=($mag_bredth, $mag_width, $mag_length)) in RelativeCS9
  coordinate_system RelativeCS10 = origin=(-sqrt($width**2*sin($angle10)**2), -$hieght*sqrt($width**2*cos($angle10)**2)/$width, 0) x=(cos(2*$angle_elips10), -sin(2*$angle_elips10), 0mm) y=(sin(2*$angle_elips10), cos(2*$angle_elips10), 0mm)
  Box10 [NdFe38, oriented by RelativeCS10] = box(corner=(-$mag_bredth/2, -$mag_width/2, -$mag_length/2), size=($mag_bredth, $mag_width, $mag_length)) in RelativeCS10
  coordinate_system RelativeCS11 = origin=(-sqrt($width**2*sin($angle11)**2), -$hieght*sqrt($width**2*cos($angle11)**2)/$width, 0) x=(cos(2*$angle_elips11), -sin(2*$angle_elips11), 0mm) y=(sin(2*$angle_elips11), cos(2*$angle_elips11), 0mm)
  Box11 [NdFe38, oriented by RelativeCS11] = box(corner=(-$mag_bredth/2, -$mag_width/2, -$mag_length/2), size=($mag_bredth, $mag_width, $mag_length)) in RelativeCS11
  coordinate_system RelativeCS12 = origin=(-$width, 0, 0) x=(cos(2*$angle12), -sin(2*$angle12), 0mm) y=(sin(2*$angle12), cos(2*$angle12), 0mm)
  Box12 [NdFe38, oriented by RelativeCS12] = box(corner=(-$mag_bredth/2, -$mag_width/2, -$mag_length/2), size=($mag_bredth, $mag_width, $mag_length)) in RelativeCS12
  coordinate_system RelativeCS13 = origin=(-sqrt($width**2*sin($angle13)**2), $hieght*sqrt($width**2*cos($angle13)**2)/$width, 0) x=(cos(2*$angle_elips13), sin(2*$angle_elips13), 0mm) y=(-sin(2*$angle_elips13), cos(2*$angle_elips13), 0mm)
  Box13 [NdFe38, oriented by RelativeCS13] = box(corner=(-$mag_bredth/2, -$mag_width/2, -$mag_length/2), size=($mag_bredth, $mag_width, $mag_length)) in RelativeCS13
  coordinate_system RelativeCS14 = origin=(-sqrt($width**2*sin($angle14)**2), $hieght*sqrt($width**2*cos($angle14)**2)/$width, 0) x=(cos(2*$angle_elips14), sin(2*$angle_elips14), 0mm) y=(-sin(2*$angle_elips14), cos(2*$angle_elips14), 0mm)
  Box14 [NdFe38, oriented by RelativeCS14] = box(corner=(-$mag_bredth/2, -$mag_width/2, -$mag_length/2), size=($mag_bredth, $mag_width, $mag_length)) in RelativeCS14
  coordinate_system RelativeCS15 = origin=(-sqrt($width**2*sin($angle15)**2), $hieght*sqrt($width**2*cos($angle15)**2)/$width, 0) x=(cos(2*$angle_elips15), sin(2*$angle_elips15), 0mm) y=(-sin(2*$angle_elips15), cos(2*$angle_elips15), 0mm)
  Box15 [NdFe38, oriented by RelativeCS15] = box(corner=(-$mag_bredth/2, -$mag_width/2, -$mag_length/2), size=($mag_bredth, $mag_width, $mag_length)) in RelativeCS15
  coordinate_system center = origin=(0mm, 0mm, (($num_of_rows-1)/2)*$length_between_row) x=(1mm, 0mm, 0mm) y=(0mm, 1mm, 0mm)
  sweet_spot_box [vacuum, non-model, oriented by center] = box(corner=(-$sweet_spot/2, -$sweet_spot/2, -$swet_spot_length/2), size=($sweet_spot, $sweet_spot, $swet_spot_length)) in center
  Rectangle1 [non-model] = rectangle(corner=(-($r+$buffer), -($r+$buffer), -$mag_length/2), x_size=($r+$buffer)*2, y_size=($r+$buffer)*2)
  Rectangle1_1..Rectangle1_15 [non-model] = Rectangle1.duplicate_along_line(step=(0mm, 0mm, $length_between_sheet), total=16) in center
  Region [air] = region(percentage_offset=800 on all sides) in center
  point Point1 = (-110000mm, -90000mm, 0mm)
  Box0_1..Box0_4 [NdFe38, oriented by RelativeCS0] = Box0.duplicate_along_line(step=(0mm, 0mm, $length_between_row), total=5)
  Box1_1..Box1_4 [NdFe38, oriented by RelativeCS1] = Box1.duplicate_along_line(step=(0mm, 0mm, $length_between_row), total=5)
  Box2_1..Box2_4 [NdFe38, oriented by RelativeCS2] = Box2.duplicate_along_line(step=(0mm, 0mm, $length_between_row), total=5)
  Box3_1..Box3_4 [NdFe38, oriented by RelativeCS3] = Box3.duplicate_along_line(step=(0mm, 0mm, $length_between_row), total=5)
  Box4_1..Box4_4 [NdFe38, oriented by RelativeCS4] = Box4.duplicate_along_line(step=(0mm, 0mm, $length_between_row), total=5)
  Box5_1..Box5_4 [NdFe38, oriented by RelativeCS5] = Box5.duplicate_along_line(step=(0mm, 0mm, $length_between_row), total=5)
  Box6_1..Box6_4 [NdFe38, oriented by RelativeCS6] = Box6.duplicate_along_line(step=(0mm, 0mm, $length_between_row), total=5)
  Box7_1..Box7_4 [NdFe38, oriented by RelativeCS7] = Box7.duplicate_along_line(step=(0mm, 0mm, $length_between_row), total=5)
  Box8_1..Box8_4 [NdFe38, oriented by RelativeCS8] = Box8.duplicate_along_line(step=(0mm, 0mm, $length_between_row), total=5)
  Box9_1..Box9_4 [NdFe38, oriented by RelativeCS9] = Box9.duplicate_along_line(step=(0mm, 0mm, $length_between_row), total=5)
  Box10_1..Box10_4 [NdFe38, oriented by RelativeCS10] = Box10.duplicate_along_line(step=(0mm, 0mm, $length_between_row), total=5)
  Box11_1..Box11_4 [NdFe38, oriented by RelativeCS11] = Box11.duplicate_along_line(step=(0mm, 0mm, $length_between_row), total=5)
  Box12_1..Box12_4 [NdFe38, oriented by RelativeCS12] = Box12.duplicate_along_line(step=(0mm, 0mm, $length_between_row), total=5)
  Box13_1..Box13_4 [NdFe38, oriented by RelativeCS13] = Box13.duplicate_along_line(step=(0mm, 0mm, $length_between_row), total=5)
  Box14_1..Box14_4 [NdFe38, oriented by RelativeCS14] = Box14.duplicate_along_line(step=(0mm, 0mm, $length_between_row), total=5)
  Box15_1..Box15_4 [NdFe38, oriented by RelativeCS15] = Box15.duplicate_along_line(step=(0mm, 0mm, $length_between_row), total=5)
  coordinate_system sph_1_7 = origin=(0, cos($Angle_between*7)*$hieght, -sin($Angle_between*7)*$hieght) x=(1, 0, 0) y=(0mm, cos($Angle_between*7), -sin($Angle_between*7))
  coordinate_system sph_1_6 = origin=(0, cos($Angle_between*6)*$hieght, -sin($Angle_between*6)*$hieght) x=(1, 0, 0) y=(0mm, cos($Angle_between*6), -sin($Angle_between*6))
  coordinate_system sph_1_5 = origin=(0, cos($Angle_between*5)*$hieght, -sin($Angle_between*5)*$hieght) x=(1, 0, 0) y=(0mm, cos($Angle_between*5), -sin($Angle_between*5))
  coordinate_system sph_1_4 = origin=(0, cos($Angle_between*4)*$hieght, -sin($Angle_between*4)*$hieght) x=(1, 0, 0) y=(0mm, cos($Angle_between*4), -sin($Angle_between*4))
  coordinate_system top = origin=(0mm, 0mm, ($length_between_row)*(5-1)) x=(1mm, 0mm, 0mm) y=(0mm, 1mm, 0mm)
  coordinate_system sph_1_9 = origin=(0, cos($Angle_between*10)*$hieght, -sin($Angle_between*10)*$hieght) x=(1, 0, 0) y=(0mm, cos($Angle_between*10), -sin($Angle_between*10)) in top
  coordinate_system sph_1_10 = origin=(0, cos($Angle_between*11)*$hieght, -sin($Angle_between*11)*$hieght) x=(1, 0, 0) y=(0mm, cos($Angle_between*11), -sin($Angle_between*11)) in top
  coordinate_system sph_1_11 = origin=(0, cos($Angle_between*12)*$hieght, -sin($Angle_between*12)*$hieght) x=(1, 0, 0) y=(0mm, cos($Angle_between*12), -sin($Angle_between*12)) in top
  coordinate_system sph_1_12 = origin=(0, cos($Angle_between*13)*$hieght, -sin($Angle_between*13)*$hieght) x=(1, 0, 0) y=(0mm, cos($Angle_between*13), -sin($Angle_between*13)) in top
  coordinate_system sph_1 = origin=(0, cos($Angle_between*1)*$hieght, -sin($Angle_between*1)*$hieght) x=(1mm, 0mm, 0mm) y=(0mm, cos($Angle_between*1), -sin($Angle_between*1))
  coordinate_system sph_1_2 = origin=(0, cos($Angle_between*2)*$hieght, -sin($Angle_between*2)*$hieght) x=(1, 0, 0) y=(0mm, cos($Angle_between*2), -sin($Angle_between*2))
  coordinate_system sph_1_3 = origin=(0, cos($Angle_between*3)*$hieght, -sin($Angle_between*3)*$hieght) x=(1, 0, 0) y=(0mm, cos($Angle_between*3), -sin($Angle_between*3))
  Box01 [NdFe38, oriented by sph_1] = box(corner=(-$mag_bredth/2, -$mag_width/2, -$mag_length/2), size=($mag_bredth, $mag_width, $mag_length)) in sph_1
  Box02 [NdFe38, oriented by sph_1_2] = box(corner=(-$mag_bredth/2, -$mag_width/2, -$mag_length/2), size=($mag_bredth, $mag_width, $mag_length)) in sph_1_2
  Box03 [NdFe38, oriented by sph_1_3] = box(corner=(-$mag_bredth/2, -$mag_width/2, -$mag_length/2), size=($mag_bredth, $mag_width, $mag_length)) in sph_1_3
  Box04 [NdFe38, oriented by sph_1_4] = box(corner=(-$mag_bredth/2, -$mag_width/2, -$mag_length/2), size=($mag_bredth, $mag_width, $mag_length)) in sph_1_4
  Box05 [NdFe38, oriented by sph_1_5] = box(corner=(-$mag_bredth/2, -$mag_width/2, -$mag_length/2), size=($mag_bredth, $mag_width, $mag_length)) in sph_1_5
  coordinate_system sph_1_8 = origin=(0mm, cos($Angle_between*9)*$hieght, -sin($Angle_between*9)*$hieght) x=(1, 0, 0) y=(0mm, cos($Angle_between*9), -sin($Angle_between*9)) in top
  coordinate_system sph_1_13 = origin=(0mm, cos($Angle_between*14)*$hieght, -sin($Angle_between*14)*$hieght) x=(1mm, 0mm, 0mm) y=(0mm, cos($Angle_between*14), -sin($Angle_between*14)) in top
  coordinate_system sph_1_14 = origin=(0mm, cos($Angle_between*15)*$hieght, -sin($Angle_between*15)*$hieght) x=(1, 0, 0) y=(0mm, cos($Angle_between*15), -sin($Angle_between*15)) in top
  Box06 [NdFe38, oriented by sph_1_6] = box(corner=(-$mag_bredth/2, -$mag_width/2, -$mag_length/2), size=($mag_bredth, $mag_width, $mag_length)) in sph_1_6
  Box07 [NdFe38, oriented by sph_1_7] = box(corner=(-$mag_bredth/2, -$mag_width/2, -$mag_length/2), size=($mag_bredth, $mag_width, $mag_length)) in sph_1_7
  Box08 [NdFe38, oriented by sph_1_8] = box(corner=(-$mag_bredth/2, -$mag_width/2, -$mag_length/2), size=($mag_bredth, $mag_width, $mag_length)) in sph_1_8
  Box09 [NdFe38, oriented by sph_1_9] = box(corner=(-$mag_bredth/2, -$mag_width/2, -$mag_length/2), size=($mag_bredth, $mag_width, $mag_length)) in sph_1_9
  Box010 [NdFe38, oriented by sph_1_10] = box(corner=(-$mag_bredth/2, -$mag_width/2, -$mag_length/2), size=($mag_bredth, $mag_width, $mag_length)) in sph_1_10
  Box011 [NdFe38, oriented by sph_1_11] = box(corner=(-$mag_bredth/2, -$mag_width/2, -$mag_length/2), size=($mag_bredth, $mag_width, $mag_length)) in sph_1_11
  Box012 [NdFe38, oriented by sph_1_12] = box(corner=(-$mag_bredth/2, -$mag_width/2, -$mag_length/2), size=($mag_bredth, $mag_width, $mag_length)) in sph_1_12
  Box013 [NdFe38, oriented by sph_1_13] = box(corner=(-$mag_bredth/2, -$mag_width/2, -$mag_length/2), size=($mag_bredth, $mag_width, $mag_length)) in sph_1_13
  Box014 [NdFe38, oriented by sph_1_14] = box(corner=(-$mag_bredth/2, -$mag_width/2, -$mag_length/2), size=($mag_bredth, $mag_width, $mag_length)) in sph_1_14
  coordinate_system sph_2_8 = origin=(sqrt($width**2*sin($angle1)**2), ($hieght*sqrt($width**2*cos($angle1)**2)/$width)*cos($Angle_between*9), -($hieght*sqrt($width**2*cos($angle1)**2)/$width)*sin($Angle_between*9)) x=(cos(2*$angle_elips1), -sin(2*$angle_elips1)*cos($Angle_between*9), sin(2*$angle_elips1)* sin($Angle_between*9)) y=(sin(2*$angle_elips1), cos(2*$angle_elips1)*cos($Angle_between*9), - cos(2*$angle_elips1)*sin($Angle_between*9)) in top
  coordinate_system sph_2_6 = origin=(sqrt($width**2*sin($angle1)**2), ($hieght*sqrt($width**2*cos($angle1)**2)/$width)*cos($Angle_between*6), -($hieght*sqrt($width**2*cos($angle1)**2)/$width)*sin($Angle_between*6)) x=(cos(2*$angle_elips1), -sin(2*$angle_elips1)*cos($Angle_between*6), sin(2*$angle_elips1)* sin($Angle_between*6)) y=(sin(2*$angle_elips1), cos(2*$angle_elips1)*cos($Angle_between*6), - cos(2*$angle_elips1)*sin($Angle_between*6))
  coordinate_system sph_2_7 = origin=(sqrt($width**2*sin($angle1)**2), ($hieght*sqrt($width**2*cos($angle1)**2)/$width)*cos($Angle_between*7), -($hieght*sqrt($width**2*cos($angle1)**2)/$width)*sin($Angle_between*7)) x=(cos(2*$angle_elips1), -sin(2*$angle_elips1)*cos($Angle_between*7), sin(2*$angle_elips1)* sin($Angle_between*7)) y=(sin(2*$angle_elips1), cos(2*$angle_elips1)*cos($Angle_between*7), - cos(2*$angle_elips1)*sin($Angle_between*7))
  coordinate_system sph_2_14 = origin=(sqrt($width**2*sin($angle1)**2), ($hieght*sqrt($width**2*cos($angle1)**2)/$width)*cos($Angle_between*15), -($hieght*sqrt($width**2*cos($angle1)**2)/$width)*sin($Angle_between*15)) x=(cos(2*$angle_elips1), -sin(2*$angle_elips15)*cos($Angle_between*1), sin(2*$angle_elips1)* sin($Angle_between*15)) y=(sin(2*$angle_elips1), cos(2*$angle_elips1)*cos($Angle_between*15), - cos(2*$angle_elips1)*sin($Angle_between*15)) in top
  coordinate_system sph_2_13 = origin=(sqrt($width**2*sin($angle1)**2), ($hieght*sqrt($width**2*cos($angle1)**2)/$width)*cos($Angle_between*14), -($hieght*sqrt($width**2*cos($angle1)**2)/$width)*sin($Angle_between*14)) x=(cos(2*$angle_elips1), -sin(2*$angle_elips1)*cos($Angle_between*14), sin(2*$angle_elips1)* sin($Angle_between*14)) y=(sin(2*$angle_elips1), cos(2*$angle_elips1)*cos($Angle_between*14), - cos(2*$angle_elips1)*sin($Angle_between*14)) in top
  coordinate_system sph_2_10 = origin=(sqrt($width**2*sin($angle1)**2), ($hieght*sqrt($width**2*cos($angle1)**2)/$width)*cos($Angle_between*11), -($hieght*sqrt($width**2*cos($angle1)**2)/$width)*sin($Angle_between*11)) x=(cos(2*$angle_elips1), -sin(2*$angle_elips1)*cos($Angle_between*11), sin(2*$angle_elips1)* sin($Angle_between*11)) y=(sin(2*$angle_elips1), cos(2*$angle_elips1)*cos($Angle_between*11), - cos(2*$angle_elips1)*sin($Angle_between*11)) in top
  coordinate_system sph_2_9 = origin=(sqrt($width**2*sin($angle1)**2), ($hieght*sqrt($width**2*cos($angle1)**2)/$width)*cos($Angle_between*10), -($hieght*sqrt($width**2*cos($angle1)**2)/$width)*sin($Angle_between*10)) x=(cos(2*$angle_elips1), -sin(2*$angle_elips1)*cos($Angle_between*10), sin(2*$angle_elips1)* sin($Angle_between*10)) y=(sin(2*$angle_elips1), cos(2*$angle_elips1)*cos($Angle_between*10), - cos(2*$angle_elips1)*sin($Angle_between*10)) in top
  coordinate_system sph_2_11 = origin=(sqrt($width**2*sin($angle1)**2), ($hieght*sqrt($width**2*cos($angle1)**2)/$width)*cos($Angle_between*12), -($hieght*sqrt($width**2*cos($angle1)**2)/$width)*sin($Angle_between*12)) x=(cos(2*$angle_elips1), -sin(2*$angle_elips1)*cos($Angle_between*12), sin(2*$angle_elips1)* sin($Angle_between*12)) y=(sin(2*$angle_elips1), cos(2*$angle_elips1)*cos($Angle_between*12), - cos(2*$angle_elips1)*sin($Angle_between*12)) in top
  coordinate_system sph_2_12 = origin=(sqrt($width**2*sin($angle1)**2), ($hieght*sqrt($width**2*cos($angle1)**2)/$width)*cos($Angle_between*13), -($hieght*sqrt($width**2*cos($angle1)**2)/$width)*sin($Angle_between*13)) x=(cos(2*$angle_elips1), -sin(2*$angle_elips13)*cos($Angle_between*1), sin(2*$angle_elips1)* sin($Angle_between*13)) y=(sin(2*$angle_elips1), cos(2*$angle_elips1)*cos($Angle_between*13), - cos(2*$angle_elips1)*sin($Angle_between*13)) in top
  coordinate_system sph_2_3 = origin=(sqrt($width**2*sin($angle1)**2), ($hieght*sqrt($width**2*cos($angle1)**2)/$width)*cos($Angle_between*3), -($hieght*sqrt($width**2*cos($angle1)**2)/$width)*sin($Angle_between*3)) x=(cos(2*$angle_elips1), -sin(2*$angle_elips1)*cos($Angle_between*3), sin(2*$angle_elips1)* sin($Angle_between*3)) y=(sin(2*$angle_elips1), cos(2*$angle_elips1)*cos($Angle_between*3), - cos(2*$angle_elips1)*sin($Angle_between*3))
  coordinate_system sph_2_2 = origin=(sqrt($width**2*sin($angle1)**2), ($hieght*sqrt($width**2*cos($angle1)**2)/$width)*cos($Angle_between*2), -($hieght*sqrt($width**2*cos($angle1)**2)/$width)*sin($Angle_between*2)) x=(cos(2*$angle_elips1), -sin(2*$angle_elips1)*cos($Angle_between*2), sin(2*$angle_elips1)* sin($Angle_between*2)) y=(sin(2*$angle_elips1), cos(2*$angle_elips1)*cos($Angle_between*2), - cos(2*$angle_elips1)*sin($Angle_between*2))
  coordinate_system sph_2_4 = origin=(sqrt($width**2*sin($angle1)**2), ($hieght*sqrt($width**2*cos($angle1)**2)/$width)*cos($Angle_between*4), -($hieght*sqrt($width**2*cos($angle1)**2)/$width)*sin($Angle_between*4)) x=(cos(2*$angle_elips1), -sin(2*$angle_elips1)*cos($Angle_between*4), sin(2*$angle_elips1)* sin($Angle_between*4)) y=(sin(2*$angle_elips1), cos(2*$angle_elips1)*cos($Angle_between*4), - cos(2*$angle_elips1)*sin($Angle_between*4))
  coordinate_system sph_2_5 = origin=(sqrt($width**2*sin($angle1)**2), ($hieght*sqrt($width**2*cos($angle1)**2)/$width)*cos($Angle_between*5), -($hieght*sqrt($width**2*cos($angle1)**2)/$width)*sin($Angle_between*5)) x=(cos(2*$angle_elips1), -sin(2*$angle_elips1)*cos($Angle_between*5), sin(2*$angle_elips1)* sin($Angle_between*5)) y=(sin(2*$angle_elips1), cos(2*$angle_elips1)*cos($Angle_between*5), - cos(2*$angle_elips1)*sin($Angle_between*5))
  coordinate_system sph_2_1 = origin=(sqrt($width**2*sin($angle1)**2), ($hieght*sqrt($width**2*cos($angle1)**2)/$width)*cos($Angle_between*1), -($hieght*sqrt($width**2*cos($angle1)**2)/$width)*sin($Angle_between*1)) x=(cos(2*$angle_elips1), -sin(2*$angle_elips1)*cos($Angle_between*1), sin(2*$angle_elips1)* sin($Angle_between*1)) y=(sin(2*$angle_elips1), cos(2*$angle_elips1)*cos($Angle_between*1), - cos(2*$angle_elips1)*sin($Angle_between*1))
  Box16 [NdFe38, oriented by sph_2_1] = box(corner=(-$mag_bredth/2, -$mag_width/2, -$mag_length/2), size=($mag_bredth, $mag_width, $mag_length)) in sph_2_1
  Box015 [NdFe38, oriented by sph_2_14] = box(corner=(-$mag_bredth/2, -$mag_width/2, -$mag_length/2), size=($mag_bredth, $mag_width, $mag_length)) in sph_2_14
  Box016 [NdFe38, oriented by sph_2_13] = box(corner=(-$mag_bredth/2, -$mag_width/2, -$mag_length/2), size=($mag_bredth, $mag_width, $mag_length)) in sph_2_13
  Box017 [NdFe38, oriented by sph_2_12] = box(corner=(-$mag_bredth/2, -$mag_width/2, -$mag_length/2), size=($mag_bredth, $mag_width, $mag_length)) in sph_2_12
  Box018 [NdFe38, oriented by sph_2_11] = box(corner=(-$mag_bredth/2, -$mag_width/2, -$mag_length/2), size=($mag_bredth, $mag_width, $mag_length)) in sph_2_11
  Box019 [NdFe38, oriented by sph_2_9] = box(corner=(-$mag_bredth/2, -$mag_width/2, -$mag_length/2), size=($mag_bredth, $mag_width, $mag_length)) in sph_2_9
  Box020 [NdFe38, oriented by sph_2_10] = box(corner=(-$mag_bredth/2, -$mag_width/2, -$mag_length/2), size=($mag_bredth, $mag_width, $mag_length)) in sph_2_10
  Box021 [NdFe38, oriented by sph_2_8] = box(corner=(-$mag_bredth/2, -$mag_width/2, -$mag_length/2), size=($mag_bredth, $mag_width, $mag_length)) in sph_2_8
  Box022 [NdFe38, oriented by sph_2_7] = box(corner=(-$mag_bredth/2, -$mag_width/2, -$mag_length/2), size=($mag_bredth, $mag_width, $mag_length)) in sph_2_7
  Box023 [NdFe38, oriented by sph_2_6] = box(corner=(-$mag_bredth/2, -$mag_width/2, -$mag_length/2), size=($mag_bredth, $mag_width, $mag_length)) in sph_2_6
  Box024 [NdFe38, oriented by sph_2_5] = box(corner=(-$mag_bredth/2, -$mag_width/2, -$mag_length/2), size=($mag_bredth, $mag_width, $mag_length)) in sph_2_5
  Box025 [NdFe38, oriented by sph_2_4] = box(corner=(-$mag_bredth/2, -$mag_width/2, -$mag_length/2), size=($mag_bredth, $mag_width, $mag_length)) in sph_2_4
  Box026 [NdFe38, oriented by sph_2_3] = box(corner=(-$mag_bredth/2, -$mag_width/2, -$mag_length/2), size=($mag_bredth, $mag_width, $mag_length)) in sph_2_3
  Box027 [NdFe38, oriented by sph_2_2] = box(corner=(-$mag_bredth/2, -$mag_width/2, -$mag_length/2), size=($mag_bredth, $mag_width, $mag_length)) in sph_2_2
  coordinate_system sph_7_12 = origin=(-sqrt($width**2*sin($angle3)**2), ($hieght*sqrt($width**2*cos($angle3)**2)/$width)*cos($Angle_between*12), -($hieght*sqrt($width**2*cos($angle3)**2)/$width)*sin($Angle_between*12)) x=(cos(2*$angle_elips3), sin(2*$angle_elips3)*cos($Angle_between*12), -sin(2*$angle_elips3)*sin($Angle_between*12)) y=(sin(2*$angle_elips3), -cos(2*$angle_elips3)*cos($Angle_between*12), cos(2*$angle_elips3)*sin($Angle_between*12)) in top
  coordinate_system sph_7_11 = origin=(-sqrt($width**2*sin($angle3)**2), ($hieght*sqrt($width**2*cos($angle3)**2)/$width)*cos($Angle_between*11), -($hieght*sqrt($width**2*cos($angle3)**2)/$width)*sin($Angle_between*11)) x=(cos(2*$angle_elips3), sin(2*$angle_elips3)*cos($Angle_between*11), -sin(2*$angle_elips3)*sin($Angle_between*11)) y=(sin(2*$angle_elips3), -cos(2*$angle_elips3)*cos($Angle_between*11), cos(2*$angle_elips3)*sin($Angle_between*11)) in top
  coordinate_system sph_6_15 = origin=(-sqrt($width**2*sin($angle2)**2), ($hieght*sqrt($width**2*cos($angle2)**2)/$width)*cos($Angle_between*15), -($hieght*sqrt($width**2*cos($angle2)**2)/$width)*sin($Angle_between*15)) x=(cos(2*$angle_elips2), sin(2*$angle_elips2)*cos($Angle_between*15), -sin(2*$angle_elips2)*sin($Angle_between*15)) y=(sin(2*$angle_elips1), -cos(2*$angle_elips1)*cos($Angle_between*15), cos(2*$angle_elips1)*sin($Angle_between*15)) in top
  coordinate_system sph_5_15 = origin=(-sqrt($width**2*sin($angle1)**2), ($hieght*sqrt($width**2*cos($angle1)**2)/$width)*cos($Angle_between*15), -($hieght*sqrt($width**2*cos($angle1)**2)/$width)*sin($Angle_between*15)) x=(cos(2*$angle_elips9), sin(2*$angle_elips9)*cos($Angle_between*15), -sin(2*$angle_elips9)*sin($Angle_between*15)) y=(sin(2*$angle_elips9), -sin(2*$angle_elips9)*cos($Angle_between*15), sin(2*$angle_elips9)*sin($Angle_between*15)) in top
  coordinate_system sph_7_14 = origin=(-sqrt($width**2*sin($angle3)**2), ($hieght*sqrt($width**2*cos($angle3)**2)/$width)*cos($Angle_between*14), -($hieght*sqrt($width**2*cos($angle3)**2)/$width)*sin($Angle_between*14)) x=(cos(2*$angle_elips3), sin(2*$angle_elips3)*cos($Angle_between*14), -sin(2*$angle_elips3)*sin($Angle_between*14)) y=(sin(2*$angle_elips3), -cos(2*$angle_elips3)*cos($Angle_between*14), cos(2*$angle_elips3)*sin($Angle_between*14)) in top
  coordinate_system sph_6_1 = origin=(-sqrt($width**2*sin($angle2)**2), ($hieght*sqrt($width**2*cos($angle2)**2)/$width)*cos($Angle_between*1), -($hieght*sqrt($width**2*cos($angle2)**2)/$width)*sin($Angle_between*1)) x=(cos(2*$angle_elips2), sin(2*$angle_elips2)*cos($Angle_between*1), -sin(2*$angle_elips2)*sin($Angle_between*1)) y=(sin(2*$angle_elips1), -cos(2*$angle_elips1)*cos($Angle_between*1), cos(2*$angle_elips1)*sin($Angle_between*1))
  coordinate_system sph_4_3 = origin=(sqrt($width**2*sin($angle3)**2), ($hieght*sqrt($width**2*cos($angle3)**2)/$width)*cos($Angle_between*3), -($hieght*sqrt($width**2*cos($angle3)**2)/$width)*sin($Angle_between*3)) x=(cos(2*$angle_elips3), -sin(2*$angle_elips3)*cos($Angle_between*3), sin(2*$angle_elips3)*sin($Angle_between*3)) y=(sin(2*$angle_elips3), cos(2*$angle_elips3)*cos($Angle_between*3), -cos(2*$angle_elips3)*sin($Angle_between*3))
  coordinate_system sph_4_11 = origin=(sqrt($width**2*sin($angle3)**2), ($hieght*sqrt($width**2*cos($angle3)**2)/$width)*cos($Angle_between*11), -($hieght*sqrt($width**2*cos($angle3)**2)/$width)*sin($Angle_between*11)) x=(cos(2*$angle_elips3), -sin(2*$angle_elips3)*cos($Angle_between*11), sin(2*$angle_elips3)*sin($Angle_between*11)) y=(sin(2*$angle_elips3), cos(2*$angle_elips3)*cos($Angle_between*11), -cos(2*$angle_elips3)*sin($Angle_between*11)) in top
  coordinate_system sph_4_4 = origin=(sqrt($width**2*sin($angle3)**2), ($hieght*sqrt($width**2*cos($angle3)**2)/$width)*cos($Angle_between*4), -($hieght*sqrt($width**2*cos($angle3)**2)/$width)*sin($Angle_between*4)) x=(cos(2*$angle_elips3), -sin(2*$angle_elips3)*cos($Angle_between*4), sin(2*$angle_elips3)*sin($Angle_between*4)) y=(sin(2*$angle_elips3), cos(2*$angle_elips3)*cos($Angle_between*4), -cos(2*$angle_elips3)*sin($Angle_between*4))
  coordinate_system sph_4_6 = origin=(sqrt($width**2*sin($angle3)**2), ($hieght*sqrt($width**2*cos($angle3)**2)/$width)*cos($Angle_between*6), -($hieght*sqrt($width**2*cos($angle3)**2)/$width)*sin($Angle_between*6)) x=(cos(2*$angle_elips3), -sin(2*$angle_elips3)*cos($Angle_between*6), sin(2*$angle_elips3)*sin($Angle_between*6)) y=(sin(2*$angle_elips3), cos(2*$angle_elips3)*cos($Angle_between*6), -cos(2*$angle_elips3)*sin($Angle_between*6))
  coordinate_system sph_4_7 = origin=(sqrt($width**2*sin($angle3)**2), ($hieght*sqrt($width**2*cos($angle3)**2)/$width)*cos($Angle_between*7), -($hieght*sqrt($width**2*cos($angle3)**2)/$width)*sin($Angle_between*7)) x=(cos(2*$angle_elips3), -sin(2*$angle_elips3)*cos($Angle_between*7), sin(2*$angle_elips3)*sin($Angle_between*7)) y=(sin(2*$angle_elips3), cos(2*$angle_elips3)*cos($Angle_between*7), -cos(2*$angle_elips3)*sin($Angle_between*7))
  coordinate_system sph_4_5 = origin=(sqrt($width**2*sin($angle3)**2), ($hieght*sqrt($width**2*cos($angle3)**2)/$width)*cos($Angle_between*5), -($hieght*sqrt($width**2*cos($angle3)**2)/$width)*sin($Angle_between*5)) x=(cos(2*$angle_elips3), -sin(2*$angle_elips3)*cos($Angle_between*5), sin(2*$angle_elips3)*sin($Angle_between*5)) y=(sin(2*$angle_elips3), cos(2*$angle_elips3)*cos($Angle_between*5), -cos(2*$angle_elips3)*sin($Angle_between*5))
  coordinate_system sph_4_9 = origin=(sqrt($width**2*sin($angle3)**2), ($hieght*sqrt($width**2*cos($angle3)**2)/$width)*cos($Angle_between*9), -($hieght*sqrt($width**2*cos($angle3)**2)/$width)*sin($Angle_between*9)) x=(cos(2*$angle_elips3), -sin(2*$angle_elips3)*cos($Angle_between*9), sin(2*$angle_elips3)*sin($Angle_between*9)) y=(sin(2*$angle_elips3), cos(2*$angle_elips3)*cos($Angle_between*9), -cos(2*$angle_elips3)*sin($Angle_between*9)) in top
  coordinate_system sph_4_12 = origin=(sqrt($width**2*sin($angle3)**2), ($hieght*sqrt($width**2*cos($angle3)**2)/$width)*cos($Angle_between*12), -($hieght*sqrt($width**2*cos($angle3)**2)/$width)*sin($Angle_between*12)) x=(cos(2*$angle_elips3), -sin(2*$angle_elips3)*cos($Angle_between*12), sin(2*$angle_elips3)*sin($Angle_between*12)) y=(sin(2*$angle_elips3), cos(2*$angle_elips3)*cos($Angle_between*12), -cos(2*$angle_elips3)*sin($Angle_between*12)) in top
  coordinate_system sph_4_10 = origin=(sqrt($width**2*sin($angle3)**2), ($hieght*sqrt($width**2*cos($angle3)**2)/$width)*cos($Angle_between*10), -($hieght*sqrt($width**2*cos($angle3)**2)/$width)*sin($Angle_between*10)) x=(cos(2*$angle_elips3), -sin(2*$angle_elips3)*cos($Angle_between*10), sin(2*$angle_elips3)*sin($Angle_between*10)) y=(sin(2*$angle_elips3), cos(2*$angle_elips3)*cos($Angle_between*10), -cos(2*$angle_elips3)*sin($Angle_between*10)) in top
  coordinate_system sph_4_13 = origin=(sqrt($width**2*sin($angle3)**2), ($hieght*sqrt($width**2*cos($angle3)**2)/$width)*cos($Angle_between*13), -($hieght*sqrt($width**2*cos($angle3)**2)/$width)*sin($Angle_between*13)) x=(cos(2*$angle_elips3), -sin(2*$angle_elips3)*cos($Angle_between*13), sin(2*$angle_elips3)*sin($Angle_between*13)) y=(sin(2*$angle_elips3), cos(2*$angle_elips3)*cos($Angle_between*13), -cos(2*$angle_elips3)*sin($Angle_between*13)) in top
  coordinate_system sph_4_14 = origin=(sqrt($width**2*sin($angle3)**2), ($hieght*sqrt($width**2*cos($angle3)**2)/$width)*cos($Angle_between*14), -($hieght*sqrt($width**2*cos($angle3)**2)/$width)*sin($Angle_between*14)) x=(cos(2*$angle_elips3), -sin(2*$angle_elips3)*cos($Angle_between*14), sin(2*$angle_elips3)*sin($Angle_between*14)) y=(sin(2*$angle_elips3), cos(2*$angle_elips3)*cos($Angle_between*14), -cos(2*$angle_elips3)*sin($Angle_between*14)) in top
  coordinate_system sph_4_15 = origin=(sqrt($width**2*sin($angle3)**2), ($hieght*sqrt($width**2*cos($angle3)**2)/$width)*cos($Angle_between*15), -($hieght*sqrt($width**2*cos($angle3)**2)/$width)*sin($Angle_between*15)) x=(cos(2*$angle_elips3), -sin(2*$angle_elips3)*cos($Angle_between*15), sin(2*$angle_elips3)*sin($Angle_between*15)) y=(sin(2*$angle_elips3), cos(2*$angle_elips3)*cos($Angle_between*15), -cos(2*$angle_elips3)*sin($Angle_between*15)) in top
  coordinate_system sph_4_1 = origin=(sqrt($width**2*sin($angle3)**2), ($hieght*sqrt($width**2*cos($angle3)**2)/$width)*cos($Angle_between*1), -($hieght*sqrt($width**2*cos($angle3)**2)/$width)*sin($Angle_between*1)) x=(cos(2*$angle_elips3), -sin(2*$angle_elips3)*cos($Angle_between*1), sin(2*$angle_elips3)*sin($Angle_between*1)) y=(sin(2*$angle_elips3), cos(2*$angle_elips3)*cos($Angle_between*1), -cos(2*$angle_elips3)*sin($Angle_between*1))
  coordinate_system sph_4_2 = origin=(sqrt($width**2*sin($angle3)**2), ($hieght*sqrt($width**2*cos($angle3)**2)/$width)*cos($Angle_between*2), -($hieght*sqrt($width**2*cos($angle3)**2)/$width)*sin($Angle_between*2)) x=(cos(2*$angle_elips3), -sin(2*$angle_elips3)*cos($Angle_between*2), sin(2*$angle_elips3)*sin($Angle_between*2)) y=(sin(2*$angle_elips3), cos(2*$angle_elips3)*cos($Angle_between*2), -cos(2*$angle_elips3)*sin($Angle_between*2))
  coordinate_system sph_3_1 = origin=(sqrt($width**2*sin($angle2)**2), ($hieght*sqrt($width**2*cos($angle2)**2)/$width)*cos($Angle_between*1), -($hieght*sqrt($width**2*cos($angle2)**2)/$width)*sin($Angle_between*1)) x=(cos(2*$angle_elips2), -sin(2*$angle_elips2)*cos($Angle_between*1), sin(2*$angle_elips2)*sin($Angle_between*1)) y=(sin(2*$angle_elips1), cos(2*$angle_elips1)*cos($Angle_between*1), -cos(2*$angle_elips1)*sin($Angle_between*1))
  coordinate_system sph_3_2 = origin=(sqrt($width**2*sin($angle2)**2), ($hieght*sqrt($width**2*cos($angle2)**2)/$width)*cos($Angle_between*2), -($hieght*sqrt($width**2*cos($angle2)**2)/$width)*sin($Angle_between*2)) x=(cos(2*$angle_elips2), -sin(2*$angle_elips2)*cos($Angle_between*2), sin(2*$angle_elips2)*sin($Angle_between*2)) y=(sin(2*$angle_elips1), cos(2*$angle_elips1)*cos($Angle_between*2), -cos(2*$angle_elips1)*sin($Angle_between*2))
  coordinate_system sph_3_4 = origin=(sqrt($width**2*sin($angle2)**2), ($hieght*sqrt($width**2*cos($angle2)**2)/$width)*cos($Angle_between*4), -($hieght*sqrt($width**2*cos($angle2)**2)/$width)*sin($Angle_between*4)) x=(cos(2*$angle_elips2), -sin(2*$angle_elips2)*cos($Angle_between*4), sin(2*$angle_elips2)*sin($Angle_between*4)) y=(sin(2*$angle_elips1), cos(2*$angle_elips1)*cos($Angle_between*4), -cos(2*$angle_elips1)*sin($Angle_between*4))
  coordinate_system sph_3_3 = origin=(sqrt($width**2*sin($angle2)**2), ($hieght*sqrt($width**2*cos($angle2)**2)/$width)*cos($Angle_between*3), -($hieght*sqrt($width**2*cos($angle2)**2)/$width)*sin($Angle_between*3)) x=(cos(2*$angle_elips2), -sin(2*$angle_elips2)*cos($Angle_between*3), sin(2*$angle_elips2)*sin($Angle_between*3)) y=(sin(2*$angle_elips1), cos(2*$angle_elips1)*cos($Angle_between*3), -cos(2*$angle_elips1)*sin($Angle_between*3))
  coordinate_system sph_3_6 = origin=(sqrt($width**2*sin($angle2)**2), ($hieght*sqrt($width**2*cos($angle2)**2)/$width)*cos($Angle_between*6), -($hieght*sqrt($width**2*cos($angle2)**2)/$width)*sin($Angle_between*6)) x=(cos(2*$angle_elips2), -sin(2*$angle_elips2)*cos($Angle_between*6), sin(2*$angle_elips2)*sin($Angle_between*6)) y=(sin(2*$angle_elips1), cos(2*$angle_elips1)*cos($Angle_between*6), -cos(2*$angle_elips1)*sin($Angle_between*6))
  coordinate_system sph_3_5 = origin=(sqrt($width**2*sin($angle2)**2), ($hieght*sqrt($width**2*cos($angle2)**2)/$width)*cos($Angle_between*5), -($hieght*sqrt($width**2*cos($angle2)**2)/$width)*sin($Angle_between*5)) x=(cos(2*$angle_elips2), -sin(2*$angle_elips2)*cos($Angle_between*5), sin(2*$angle_elips2)*sin($Angle_between*5)) y=(sin(2*$angle_elips1), cos(2*$angle_elips1)*cos($Angle_between*5), -cos(2*$angle_elips1)*sin($Angle_between*5))
  coordinate_system sph_3_7 = origin=(sqrt($width**2*sin($angle2)**2), ($hieght*sqrt($width**2*cos($angle2)**2)/$width)*cos($Angle_between*7), -($hieght*sqrt($width**2*cos($angle2)**2)/$width)*sin($Angle_between*7)) x=(cos(2*$angle_elips2), -sin(2*$angle_elips2)*cos($Angle_between*7), sin(2*$angle_elips2)*sin($Angle_between*7)) y=(sin(2*$angle_elips1), cos(2*$angle_elips1)*cos($Angle_between*7), -cos(2*$angle_elips1)*sin($Angle_between*7))
  coordinate_system sph_3_10 = origin=(sqrt($width**2*sin($angle2)**2), ($hieght*sqrt($width**2*cos($angle2)**2)/$width)*cos($Angle_between*10), -($hieght*sqrt($width**2*cos($angle2)**2)/$width)*sin($Angle_between*10)) x=(cos(2*$angle_elips2), -sin(2*$angle_elips2)*cos($Angle_between*10), sin(2*$angle_elips2)*sin($Angle_between*10)) y=(sin(2*$angle_elips1), cos(2*$angle_elips1)*cos($Angle_between*10), -cos(2*$angle_elips1)*sin($Angle_between*10)) in top
  coordinate_system sph_3_11 = origin=(sqrt($width**2*sin($angle2)**2), ($hieght*sqrt($width**2*cos($angle2)**2)/$width)*cos($Angle_between*11), -($hieght*sqrt($width**2*cos($angle2)**2)/$width)*sin($Angle_between*11)) x=(cos(2*$angle_elips2), -sin(2*$angle_elips2)*cos($Angle_between*11), sin(2*$angle_elips2)*sin($Angle_between*11)) y=(sin(2*$angle_elips1), cos(2*$angle_elips1)*cos($Angle_between*11), -cos(2*$angle_elips1)*sin($Angle_between*11)) in top
  coordinate_system sph_3_12 = origin=(sqrt($width**2*sin($angle2)**2), ($hieght*sqrt($width**2*cos($angle2)**2)/$width)*cos($Angle_between*12), -($hieght*sqrt($width**2*cos($angle2)**2)/$width)*sin($Angle_between*12)) x=(cos(2*$angle_elips2), -sin(2*$angle_elips2)*cos($Angle_between*12), sin(2*$angle_elips2)*sin($Angle_between*12)) y=(sin(2*$angle_elips1), cos(2*$angle_elips2)*cos($Angle_between*12), -cos(2*$angle_elips1)*sin($Angle_between*12)) in top
  coordinate_system sph_3_13 = origin=(sqrt($width**2*sin($angle2)**2), ($hieght*sqrt($width**2*cos($angle2)**2)/$width)*cos($Angle_between*13), -($hieght*sqrt($width**2*cos($angle2)**2)/$width)*sin($Angle_between*13)) x=(cos(2*$angle_elips2), -sin(2*$angle_elips2)*cos($Angle_between*13), sin(2*$angle_elips2)*sin($Angle_between*13)) y=(sin(2*$angle_elips1), cos(2*$angle_elips1)*cos($Angle_between*13), -cos(2*$angle_elips1)*sin($Angle_between*13)) in top
  coordinate_system sph_3_14 = origin=(sqrt($width**2*sin($angle2)**2), ($hieght*sqrt($width**2*cos($angle2)**2)/$width)*cos($Angle_between*14), -($hieght*sqrt($width**2*cos($angle2)**2)/$width)*sin($Angle_between*14)) x=(cos(2*$angle_elips2), -sin(2*$angle_elips2)*cos($Angle_between*14), sin(2*$angle_elips2)*sin($Angle_between*14)) y=(sin(2*$angle_elips1), cos(2*$angle_elips1)*cos($Angle_between*14), -cos(2*$angle_elips1)*sin($Angle_between*14)) in top
  coordinate_system sph_3_9 = origin=(sqrt($width**2*sin($angle2)**2), ($hieght*sqrt($width**2*cos($angle2)**2)/$width)*cos($Angle_between*9), -($hieght*sqrt($width**2*cos($angle2)**2)/$width)*sin($Angle_between*9)) x=(cos(2*$angle_elips2), -sin(2*$angle_elips2)*cos($Angle_between*9), sin(2*$angle_elips2)*sin($Angle_between*9)) y=(sin(2*$angle_elips1), cos(2*$angle_elips1)*cos($Angle_between*9), -cos(2*$angle_elips1)*sin($Angle_between*9)) in top
  coordinate_system sph_3_15 = origin=(sqrt($width**2*sin($angle2)**2), ($hieght*sqrt($width**2*cos($angle2)**2)/$width)*cos($Angle_between*15), -($hieght*sqrt($width**2*cos($angle2)**2)/$width)*sin($Angle_between*15)) x=(cos(2*$angle_elips2), -sin(2*$angle_elips2)*cos($Angle_between*15), sin(2*$angle_elips2)*sin($Angle_between*15)) y=(sin(2*$angle_elips1), cos(2*$angle_elips1)*cos($Angle_between*15), -cos(2*$angle_elips1)*sin($Angle_between*15)) in top
  Box028 [NdFe38, oriented by sph_3_1] = box(corner=(-$mag_bredth/2, -$mag_width/2, -$mag_length/2), size=($mag_bredth, $mag_width, $mag_length)) in sph_3_1
  Box029 [NdFe38, oriented by sph_3_2] = box(corner=(-$mag_bredth/2, -$mag_width/2, -$mag_length/2), size=($mag_bredth, $mag_width, $mag_length)) in sph_3_2
  Box030 [NdFe38, oriented by sph_3_3] = box(corner=(-$mag_bredth/2, -$mag_width/2, -$mag_length/2), size=($mag_bredth, $mag_width, $mag_length)) in sph_3_3
  Box031 [NdFe38, oriented by sph_3_4] = box(corner=(-$mag_bredth/2, -$mag_width/2, -$mag_length/2), size=($mag_bredth, $mag_width, $mag_length)) in sph_3_4
  Box032 [NdFe38, oriented by sph_3_5] = box(corner=(-$mag_bredth/2, -$mag_width/2, -$mag_length/2), size=($mag_bredth, $mag_width, $mag_length)) in sph_3_5
  Box033 [NdFe38, oriented by sph_3_6] = box(corner=(-$mag_bredth/2, -$mag_width/2, -$mag_length/2), size=($mag_bredth, $mag_width, $mag_length)) in sph_3_6
  Box034 [NdFe38, oriented by sph_3_7] = box(corner=(-$mag_bredth/2, -$mag_width/2, -$mag_length/2), size=($mag_bredth, $mag_width, $mag_length)) in sph_3_7
  Box035 [NdFe38, oriented by sph_3_9] = box(corner=(-$mag_bredth/2, -$mag_width/2, -$mag_length/2), size=($mag_bredth, $mag_width, $mag_length)) in sph_3_9
  Box036 [NdFe38, oriented by sph_3_10] = box(corner=(-$mag_bredth/2, -$mag_width/2, -$mag_length/2), size=($mag_bredth, $mag_width, $mag_length)) in sph_3_10
  Box037 [NdFe38, oriented by sph_3_11] = box(corner=(-$mag_bredth/2, -$mag_width/2, -$mag_length/2), size=($mag_bredth, $mag_width, $mag_length)) in sph_3_11
  Box038 [NdFe38, oriented by sph_3_12] = box(corner=(-$mag_bredth/2, -$mag_width/2, -$mag_length/2), size=($mag_bredth, $mag_width, $mag_length)) in sph_3_12
  Box039 [NdFe38, oriented by sph_3_13] = box(corner=(-$mag_bredth/2, -$mag_width/2, -$mag_length/2), size=($mag_bredth, $mag_width, $mag_length)) in sph_3_13
  Box040 [NdFe38, oriented by sph_3_14] = box(corner=(-$mag_bredth/2, -$mag_width/2, -$mag_length/2), size=($mag_bredth, $mag_width, $mag_length)) in sph_3_14
  Box041 [NdFe38, oriented by sph_3_15] = box(corner=(-$mag_bredth/2, -$mag_width/2, -$mag_length/2), size=($mag_bredth, $mag_width, $mag_length)) in sph_3_15
  Box042 [NdFe38, oriented by sph_4_1] = box(corner=(-$mag_bredth/2, -$mag_width/2, -$mag_length/2), size=($mag_bredth, $mag_width, $mag_length)) in sph_4_1
  Box043 [NdFe38, oriented by sph_4_2] = box(corner=(-$mag_bredth/2, -$mag_width/2, -$mag_length/2), size=($mag_bredth, $mag_width, $mag_length)) in sph_4_2
  Box044 [NdFe38, oriented by sph_4_3] = box(corner=(-$mag_bredth/2, -$mag_width/2, -$mag_length/2), size=($mag_bredth, $mag_width, $mag_length)) in sph_4_3
  Box045 [NdFe38, oriented by sph_4_4] = box(corner=(-$mag_bredth/2, -$mag_width/2, -$mag_length/2), size=($mag_bredth, $mag_width, $mag_length)) in sph_4_4
  Box046 [NdFe38, oriented by sph_4_5] = box(corner=(-$mag_bredth/2, -$mag_width/2, -$mag_length/2), size=($mag_bredth, $mag_width, $mag_length)) in sph_4_5
  Box047 [NdFe38, oriented by sph_4_6] = box(corner=(-$mag_bredth/2, -$mag_width/2, -$mag_length/2), size=($mag_bredth, $mag_width, $mag_length)) in sph_4_6
  Box048 [NdFe38, oriented by sph_4_7] = box(corner=(-$mag_bredth/2, -$mag_width/2, -$mag_length/2), size=($mag_bredth, $mag_width, $mag_length)) in sph_4_7
  Box049 [NdFe38, oriented by sph_4_9] = box(corner=(-$mag_bredth/2, -$mag_width/2, -$mag_length/2), size=($mag_bredth, $mag_width, $mag_length)) in sph_4_9
  Box050 [NdFe38, oriented by sph_4_10] = box(corner=(-$mag_bredth/2, -$mag_width/2, -$mag_length/2), size=($mag_bredth, $mag_width, $mag_length)) in sph_4_10
  Box051 [NdFe38, oriented by sph_4_11] = box(corner=(-$mag_bredth/2, -$mag_width/2, -$mag_length/2), size=($mag_bredth, $mag_width, $mag_length)) in sph_4_11
  Box052 [NdFe38] = box(corner=(-$mag_bredth/2, -$mag_width/2, -$mag_length/2), size=($mag_bredth, $mag_width, $mag_length)) in sph_4_12
  Box053 [NdFe38, oriented by sph_4_12] = box(corner=(-$mag_bredth/2, -$mag_width/2, -$mag_length/2), size=($mag_bredth, $mag_width, $mag_length)) in sph_4_12
  Box054 [NdFe38, oriented by sph_4_13] = box(corner=(-$mag_bredth/2, -$mag_width/2, -$mag_length/2), size=($mag_bredth, $mag_width, $mag_length)) in sph_4_13
  Box055 [NdFe38, oriented by sph_4_14] = box(corner=(-$mag_bredth/2, -$mag_width/2, -$mag_length/2), size=($mag_bredth, $mag_width, $mag_length)) in sph_4_14
  Box056 [NdFe38, oriented by sph_4_15] = box(corner=(-$mag_bredth/2, -$mag_width/2, -$mag_length/2), size=($mag_bredth, $mag_width, $mag_length)) in sph_4_15
  coordinate_system sph_6_2 = origin=(-sqrt($width**2*sin($angle2)**2), ($hieght*sqrt($width**2*cos($angle2)**2)/$width)*cos($Angle_between*2), -($hieght*sqrt($width**2*cos($angle2)**2)/$width)*sin($Angle_between*2)) x=(cos(2*$angle_elips2), sin(2*$angle_elips2)*cos($Angle_between*2), -sin(2*$angle_elips2)*sin($Angle_between*2)) y=(sin(2*$angle_elips1), -cos(2*$angle_elips1)*cos($Angle_between*2), cos(2*$angle_elips1)*sin($Angle_between*2))
  coordinate_system sph_6_3 = origin=(-sqrt($width**2*sin($angle2)**2), ($hieght*sqrt($width**2*cos($angle2)**2)/$width)*cos($Angle_between*3), -($hieght*sqrt($width**2*cos($angle2)**2)/$width)*sin($Angle_between*3)) x=(cos(2*$angle_elips2), sin(2*$angle_elips2)*cos($Angle_between*3), -sin(2*$angle_elips2)*sin($Angle_between*3)) y=(sin(2*$angle_elips1), -cos(2*$angle_elips1)*cos($Angle_between*3), cos(2*$angle_elips1)*sin($Angle_between*3))
  coordinate_system sph_6_4 = origin=(-sqrt($width**2*sin($angle2)**2), ($hieght*sqrt($width**2*cos($angle2)**2)/$width)*cos($Angle_between*4), -($hieght*sqrt($width**2*cos($angle2)**2)/$width)*sin($Angle_between*4)) x=(cos(2*$angle_elips2), sin(2*$angle_elips2)*cos($Angle_between*4), -sin(2*$angle_elips2)*sin($Angle_between*4)) y=(sin(2*$angle_elips1), -cos(2*$angle_elips1)*cos($Angle_between*4), cos(2*$angle_elips1)*sin($Angle_between*4))
  coordinate_system sph_6_5 = origin=(-sqrt($width**2*sin($angle2)**2), ($hieght*sqrt($width**2*cos($angle2)**2)/$width)*cos($Angle_between*5), -($hieght*sqrt($width**2*cos($angle2)**2)/$width)*sin($Angle_between*5)) x=(cos(2*$angle_elips2), sin(2*$angle_elips2)*cos($Angle_between*5), -sin(2*$angle_elips2)*sin($Angle_between*5)) y=(sin(2*$angle_elips1), -cos(2*$angle_elips1)*cos($Angle_between*5), cos(2*$angle_elips1)*sin($Angle_between*5))
  coordinate_system sph_6_6 = origin=(-sqrt($width**2*sin($angle2)**2), ($hieght*sqrt($width**2*cos($angle2)**2)/$width)*cos($Angle_between*6), -($hieght*sqrt($width**2*cos($angle2)**2)/$width)*sin($Angle_between*6)) x=(cos(2*$angle_elips2), sin(2*$angle_elips2)*cos($Angle_between*6), -sin(2*$angle_elips2)*sin($Angle_between*6)) y=(sin(2*$angle_elips1), -cos(2*$angle_elips1)*cos($Angle_between*6), cos(2*$angle_elips1)*sin($Angle_between*6))
  coordinate_system sph_6_11 = origin=(-sqrt($width**2*sin($angle2)**2), ($hieght*sqrt($width**2*cos($angle2)**2)/$width)*cos($Angle_between*11), -($hieght*sqrt($width**2*cos($angle2)**2)/$width)*sin($Angle_between*11)) x=(cos(2*$angle_elips2), sin(2*$angle_elips2)*cos($Angle_between*11), -sin(2*$angle_elips2)*sin($Angle_between*11)) y=(sin(2*$angle_elips1), -cos(2*$angle_elips1)*cos($Angle_between*11), cos(2*$angle_elips1)*sin($Angle_between*11)) in top
  coordinate_system sph_6_10 = origin=(-sqrt($width**2*sin($angle2)**2), ($hieght*sqrt($width**2*cos($angle2)**2)/$width)*cos($Angle_between*10), -($hieght*sqrt($width**2*cos($angle2)**2)/$width)*sin($Angle_between*10)) x=(cos(2*$angle_elips2), sin(2*$angle_elips2)*cos($Angle_between*10), -sin(2*$angle_elips2)*sin($Angle_between*10)) y=(sin(2*$angle_elips1), -cos(2*$angle_elips1)*cos($Angle_between*10), cos(2*$angle_elips1)*sin($Angle_between*10)) in top
  coordinate_system sph_6_12 = origin=(-sqrt($width**2*sin($angle2)**2), ($hieght*sqrt($width**2*cos($angle2)**2)/$width)*cos($Angle_between*12), -($hieght*sqrt($width**2*cos($angle2)**2)/$width)*sin($Angle_between*12)) x=(cos(2*$angle_elips2), sin(2*$angle_elips2)*cos($Angle_between*12), -sin(2*$angle_elips2)*sin($Angle_between*12)) y=(sin(2*$angle_elips1), -cos(2*$angle_elips1)*cos($Angle_between*12), cos(2*$angle_elips1)*sin($Angle_between*12)) in top
  coordinate_system sph_6_9 = origin=(-sqrt($width**2*sin($angle2)**2), ($hieght*sqrt($width**2*cos($angle2)**2)/$width)*cos($Angle_between*9), -($hieght*sqrt($width**2*cos($angle2)**2)/$width)*sin($Angle_between*9)) x=(cos(2*$angle_elips2), sin(2*$angle_elips2)*cos($Angle_between*9), -sin(2*$angle_elips2)*sin($Angle_between*9)) y=(sin(2*$angle_elips1), -cos(2*$angle_elips1)*cos($Angle_between*9), cos(2*$angle_elips1)*sin($Angle_between*9)) in top
  coordinate_system sph_6_7 = origin=(-sqrt($width**2*sin($angle2)**2), ($hieght*sqrt($width**2*cos($angle2)**2)/$width)*cos($Angle_between*7), -($hieght*sqrt($width**2*cos($angle2)**2)/$width)*sin($Angle_between*7)) x=(cos(2*$angle_elips2), sin(2*$angle_elips2)*cos($Angle_between*7), -sin(2*$angle_elips2)*sin($Angle_between*7)) y=(sin(2*$angle_elips1), -cos(2*$angle_elips1)*cos($Angle_between*7), cos(2*$angle_elips1)*sin($Angle_between*7))
  coordinate_system sph_5_6 = origin=(-sqrt($width**2*sin($angle1)**2), ($hieght*sqrt($width**2*cos($angle1)**2)/$width)*cos($Angle_between*6), -($hieght*sqrt($width**2*cos($angle1)**2)/$width)*sin($Angle_between*6)) x=(cos(2*$angle_elips9), sin(2*$angle_elips9)*cos($Angle_between*6), -sin(2*$angle_elips9)*sin($Angle_between*6)) y=(sin(2*$angle_elips9), -sin(2*$angle_elips9)*cos($Angle_between*6), sin(2*$angle_elips9)*sin($Angle_between*6))
  coordinate_system sph_5_7 = origin=(-sqrt($width**2*sin($angle1)**2), ($hieght*sqrt($width**2*cos($angle1)**2)/$width)*cos($Angle_between*7), -($hieght*sqrt($width**2*cos($angle1)**2)/$width)*sin($Angle_between*7)) x=(cos(2*$angle_elips9), sin(2*$angle_elips9)*cos($Angle_between*7), -sin(2*$angle_elips9)*sin($Angle_between*7)) y=(sin(2*$angle_elips9), -sin(2*$angle_elips9)*cos($Angle_between*7), sin(2*$angle_elips9)*sin($Angle_between*7))
  coordinate_system sph_5_9 = origin=(-sqrt($width**2*sin($angle1)**2), ($hieght*sqrt($width**2*cos($angle1)**2)/$width)*cos($Angle_between*9), -($hieght*sqrt($width**2*cos($angle1)**2)/$width)*sin($Angle_between*9)) x=(cos(2*$angle_elips9), sin(2*$angle_elips9)*cos($Angle_between*8), -sin(2*$angle_elips9)*sin($Angle_between*9)) y=(sin(2*$angle_elips9), -sin(2*$angle_elips9)*cos($Angle_between*8), sin(2*$angle_elips9)*sin($Angle_between*9)) in top
  coordinate_system sph_5_10 = origin=(-sqrt($width**2*sin($angle1)**2), ($hieght*sqrt($width**2*cos($angle1)**2)/$width)*cos($Angle_between*10), -($hieght*sqrt($width**2*cos($angle1)**2)/$width)*sin($Angle_between*10)) x=(cos(2*$angle_elips9), sin(2*$angle_elips9)*cos($Angle_between*10), -sin(2*$angle_elips10)*sin($Angle_between*10)) y=(sin(2*$angle_elips9), -sin(2*$angle_elips9)*cos($Angle_between*10), sin(2*$angle_elips9)*sin($Angle_between*10)) in top
  coordinate_system sph_5_11 = origin=(-sqrt($width**2*sin($angle1)**2), ($hieght*sqrt($width**2*cos($angle1)**2)/$width)*cos($Angle_between*11), -($hieght*sqrt($width**2*cos($angle1)**2)/$width)*sin($Angle_between*11)) x=(cos(2*$angle_elips9), sin(2*$angle_elips9)*cos($Angle_between*11), -sin(2*$angle_elips9)*sin($Angle_between*11)) y=(sin(2*$angle_elips9), -sin(2*$angle_elips9)*cos($Angle_between*11), sin(2*$angle_elips9)*sin($Angle_between*11)) in top
  coordinate_system sph_5_12 = origin=(-sqrt($width**2*sin($angle1)**2), ($hieght*sqrt($width**2*cos($angle1)**2)/$width)*cos($Angle_between*12), -($hieght*sqrt($width**2*cos($angle1)**2)/$width)*sin($Angle_between*12)) x=(cos(2*$angle_elips9), sin(2*$angle_elips9)*cos($Angle_between*12), -sin(2*$angle_elips9)*sin($Angle_between*12)) y=(sin(2*$angle_elips9), -sin(2*$angle_elips9)*cos($Angle_between*12), sin(2*$angle_elips9)*sin($Angle_between*12)) in top
  coordinate_system sph_5_14 = origin=(-sqrt($width**2*sin($angle1)**2), ($hieght*sqrt($width**2*cos($angle1)**2)/$width)*cos($Angle_between*14), -($hieght*sqrt($width**2*cos($angle1)**2)/$width)*sin($Angle_between*14)) x=(cos(2*$angle_elips9), sin(2*$angle_elips9)*cos($Angle_between*14), -sin(2*$angle_elips9)*sin($Angle_between*14)) y=(sin(2*$angle_elips9), -sin(2*$angle_elips9)*cos($Angle_between*14), sin(2*$angle_elips9)*sin($Angle_between*14)) in top
  coordinate_system sph_5_13 = origin=(-sqrt($width**2*sin($angle1)**2), ($hieght*sqrt($width**2*cos($angle1)**2)/$width)*cos($Angle_between*13), -($hieght*sqrt($width**2*cos($angle1)**2)/$width)*sin($Angle_between*13)) x=(cos(2*$angle_elips9), sin(2*$angle_elips9)*cos($Angle_between*13), -sin(2*$angle_elips9)*sin($Angle_between*13)) y=(sin(2*$angle_elips9), -sin(2*$angle_elips9)*cos($Angle_between*13), sin(2*$angle_elips9)*sin($Angle_between*13)) in top
  coordinate_system sph_5_4 = origin=(-sqrt($width**2*sin($angle1)**2), ($hieght*sqrt($width**2*cos($angle1)**2)/$width)*cos($Angle_between*4), -($hieght*sqrt($width**2*cos($angle1)**2)/$width)*sin($Angle_between*4)) x=(cos(2*$angle_elips9), sin(2*$angle_elips9)*cos($Angle_between*4), -sin(2*$angle_elips9)*sin($Angle_between*4)) y=(sin(2*$angle_elips9), -sin(2*$angle_elips9)*cos($Angle_between*4), sin(2*$angle_elips9)*sin($Angle_between*4))
  coordinate_system sph_6_14 = origin=(-sqrt($width**2*sin($angle2)**2), ($hieght*sqrt($width**2*cos($angle2)**2)/$width)*cos($Angle_between*14), -($hieght*sqrt($width**2*cos($angle2)**2)/$width)*sin($Angle_between*14)) x=(cos(2*$angle_elips2), sin(2*$angle_elips2)*cos($Angle_between*14), -sin(2*$angle_elips2)*sin($Angle_between*14)) y=(sin(2*$angle_elips1), -cos(2*$angle_elips1)*cos($Angle_between*14), cos(2*$angle_elips1)*sin($Angle_between*14)) in top
  coordinate_system sph_5_2 = origin=(-sqrt($width**2*sin($angle1)**2), ($hieght*sqrt($width**2*cos($angle1)**2)/$width)*cos($Angle_between*2), -($hieght*sqrt($width**2*cos($angle1)**2)/$width)*sin($Angle_between*2)) x=(cos(2*$angle_elips9), sin(2*$angle_elips9)*cos($Angle_between*2), -sin(2*$angle_elips9)*sin($Angle_between*2)) y=(sin(2*$angle_elips9), -sin(2*$angle_elips9)*cos($Angle_between*2), sin(2*$angle_elips9)*sin($Angle_between*2))
  coordinate_system sph_5_3 = origin=(-sqrt($width**2*sin($angle1)**2), ($hieght*sqrt($width**2*cos($angle1)**2)/$width)*cos($Angle_between*3), -($hieght*sqrt($width**2*cos($angle1)**2)/$width)*sin($Angle_between*3)) x=(cos(2*$angle_elips9), sin(2*$angle_elips9)*cos($Angle_between*3), -sin(2*$angle_elips9)*sin($Angle_between*3)) y=(sin(2*$angle_elips9), -sin(2*$angle_elips9)*cos($Angle_between*3), sin(2*$angle_elips9)*sin($Angle_between*3))
  coordinate_system sph_5_5 = origin=(-sqrt($width**2*sin($angle1)**2), ($hieght*sqrt($width**2*cos($angle1)**2)/$width)*cos($Angle_between*5), -($hieght*sqrt($width**2*cos($angle1)**2)/$width)*sin($Angle_between*5)) x=(cos(2*$angle_elips9), sin(2*$angle_elips9)*cos($Angle_between*5), -sin(2*$angle_elips9)*sin($Angle_between*5)) y=(sin(2*$angle_elips9), -sin(2*$angle_elips9)*cos($Angle_between*5), sin(2*$angle_elips9)*sin($Angle_between*5))
  coordinate_system sph_5_1 = origin=(-sqrt($width**2*sin($angle1)**2), ($hieght*sqrt($width**2*cos($angle1)**2)/$width)*cos($Angle_between*1), -($hieght*sqrt($width**2*cos($angle1)**2)/$width)*sin($Angle_between*1)) x=(cos(2*$angle_elips9), sin(2*$angle_elips9)*cos($Angle_between*1), -sin(2*$angle_elips9)*sin($Angle_between*1)) y=(sin(2*$angle_elips9), -sin(2*$angle_elips9)*cos($Angle_between*1), sin(2*$angle_elips9)*sin($Angle_between*1))
  coordinate_system sph_7_2 = origin=(-sqrt($width**2*sin($angle3)**2), ($hieght*sqrt($width**2*cos($angle3)**2)/$width)*cos($Angle_between*2), -($hieght*sqrt($width**2*cos($angle3)**2)/$width)*sin($Angle_between*2)) x=(cos(2*$angle_elips3), sin(2*$angle_elips3)*cos($Angle_between*2), -sin(2*$angle_elips3)*sin($Angle_between*2)) y=(sin(2*$angle_elips3), -cos(2*$angle_elips3)*cos($Angle_between*2), cos(2*$angle_elips3)*sin($Angle_between*2))
  coordinate_system sph_7_15 = origin=(-sqrt($width**2*sin($angle3)**2), ($hieght*sqrt($width**2*cos($angle3)**2)/$width)*cos($Angle_between*15), -($hieght*sqrt($width**2*cos($angle3)**2)/$width)*sin($Angle_between*15)) x=(cos(2*$angle_elips3), sin(2*$angle_elips3)*cos($Angle_between*15), -sin(2*$angle_elips3)*sin($Angle_between*15)) y=(sin(2*$angle_elips3), -cos(2*$angle_elips3)*cos($Angle_between*15), cos(2*$angle_elips3)*sin($Angle_between*15)) in top
  coordinate_system sph_7_3 = origin=(-sqrt($width**2*sin($angle3)**2), ($hieght*sqrt($width**2*cos($angle3)**2)/$width)*cos($Angle_between*3), -($hieght*sqrt($width**2*cos($angle3)**2)/$width)*sin($Angle_between*3)) x=(cos(2*$angle_elips3), sin(2*$angle_elips3)*cos($Angle_between*3), -sin(2*$angle_elips3)*sin($Angle_between*3)) y=(sin(2*$angle_elips3), -cos(2*$angle_elips3)*cos($Angle_between*3), cos(2*$angle_elips3)*sin($Angle_between*3))
  coordinate_system sph_7_1 = origin=(-sqrt($width**2*sin($angle3)**2), ($hieght*sqrt($width**2*cos($angle3)**2)/$width)*cos($Angle_between*1), -($hieght*sqrt($width**2*cos($angle3)**2)/$width)*sin($Angle_between*1)) x=(cos(2*$angle_elips3), sin(2*$angle_elips3)*cos($Angle_between*1), -sin(2*$angle_elips3)*sin($Angle_between*1)) y=(sin(2*$angle_elips3), -cos(2*$angle_elips3)*cos($Angle_between*1), cos(2*$angle_elips3)*sin($Angle_between*1))
  coordinate_system sph_7_4 = origin=(-sqrt($width**2*sin($angle3)**2), ($hieght*sqrt($width**2*cos($angle3)**2)/$width)*cos($Angle_between*4), -($hieght*sqrt($width**2*cos($angle3)**2)/$width)*sin($Angle_between*4)) x=(cos(2*$angle_elips3), sin(2*$angle_elips3)*cos($Angle_between*4), -sin(2*$angle_elips3)*sin($Angle_between*4)) y=(sin(2*$angle_elips3), -cos(2*$angle_elips3)*cos($Angle_between*4), cos(2*$angle_elips3)*sin($Angle_between*4))
  coordinate_system sph_7_5 = origin=(-sqrt($width**2*sin($angle3)**2), ($hieght*sqrt($width**2*cos($angle3)**2)/$width)*cos($Angle_between*5), -($hieght*sqrt($width**2*cos($angle3)**2)/$width)*sin($Angle_between*5)) x=(cos(2*$angle_elips3), sin(2*$angle_elips3)*cos($Angle_between*5), -sin(2*$angle_elips3)*sin($Angle_between*5)) y=(sin(2*$angle_elips3), -cos(2*$angle_elips3)*cos($Angle_between*5), cos(2*$angle_elips3)*sin($Angle_between*5))
  coordinate_system sph_7_6 = origin=(-sqrt($width**2*sin($angle3)**2), ($hieght*sqrt($width**2*cos($angle3)**2)/$width)*cos($Angle_between*6), -($hieght*sqrt($width**2*cos($angle3)**2)/$width)*sin($Angle_between*6)) x=(cos(2*$angle_elips3), sin(2*$angle_elips3)*cos($Angle_between*6), -sin(2*$angle_elips3)*sin($Angle_between*6)) y=(sin(2*$angle_elips3), -cos(2*$angle_elips3)*cos($Angle_between*6), cos(2*$angle_elips3)*sin($Angle_between*6))
  coordinate_system sph_7_13 = origin=(-sqrt($width**2*sin($angle3)**2), ($hieght*sqrt($width**2*cos($angle3)**2)/$width)*cos($Angle_between*13), -($hieght*sqrt($width**2*cos($angle3)**2)/$width)*sin($Angle_between*13)) x=(cos(2*$angle_elips3), sin(2*$angle_elips3)*cos($Angle_between*13), -sin(2*$angle_elips3)*sin($Angle_between*13)) y=(sin(2*$angle_elips3), -cos(2*$angle_elips3)*cos($Angle_between*13), cos(2*$angle_elips3)*sin($Angle_between*13)) in top
  coordinate_system sph_7_7 = origin=(-sqrt($width**2*sin($angle3)**2), ($hieght*sqrt($width**2*cos($angle3)**2)/$width)*cos($Angle_between*7), -($hieght*sqrt($width**2*cos($angle3)**2)/$width)*sin($Angle_between*7)) x=(cos(2*$angle_elips3), sin(2*$angle_elips3)*cos($Angle_between*7), -sin(2*$angle_elips3)*sin($Angle_between*7)) y=(sin(2*$angle_elips3), -cos(2*$angle_elips3)*cos($Angle_between*7), cos(2*$angle_elips3)*sin($Angle_between*7))
  coordinate_system sph_7_10 = origin=(-sqrt($width**2*sin($angle3)**2), ($hieght*sqrt($width**2*cos($angle3)**2)/$width)*cos($Angle_between*10), -($hieght*sqrt($width**2*cos($angle3)**2)/$width)*sin($Angle_between*10)) x=(cos(2*$angle_elips3), sin(2*$angle_elips3)*cos($Angle_between*10), -sin(2*$angle_elips3)*sin($Angle_between*10)) y=(sin(2*$angle_elips3), -cos(2*$angle_elips3)*cos($Angle_between*10), cos(2*$angle_elips3)*sin($Angle_between*10)) in top
  Box057 [NdFe38, oriented by sph_5_15] = box(corner=(-$mag_bredth/2, -$mag_width/2, -$mag_length/2), size=($mag_bredth, $mag_width, $mag_length)) in sph_5_15
  Box058 [NdFe38, oriented by sph_5_1] = box(corner=(-$mag_bredth/2, -$mag_width/2, -$mag_length/2), size=($mag_bredth, $mag_width, $mag_length)) in sph_5_1
  Box059 [NdFe38, oriented by sph_5_2] = box(corner=(-$mag_bredth/2, -$mag_width/2, -$mag_length/2), size=($mag_bredth, $mag_width, $mag_length)) in sph_5_2
  Box060 [NdFe38, oriented by sph_5_3] = box(corner=(-$mag_bredth/2, -$mag_width/2, -$mag_length/2), size=($mag_bredth, $mag_width, $mag_length)) in sph_5_3
  Box061 [NdFe38, oriented by sph_5_4] = box(corner=(-$mag_bredth/2, -$mag_width/2, -$mag_length/2), size=($mag_bredth, $mag_width, $mag_length)) in sph_5_4
  Box062 [NdFe38, oriented by sph_5_5] = box(corner=(-$mag_bredth/2, -$mag_width/2, -$mag_length/2), size=($mag_bredth, $mag_width, $mag_length)) in sph_5_5
  Box063 [NdFe38, oriented by sph_5_6] = box(corner=(-$mag_bredth/2, -$mag_width/2, -$mag_length/2), size=($mag_bredth, $mag_width, $mag_length)) in sph_5_6
  Box064 [NdFe38, oriented by sph_5_7] = box(corner=(-$mag_bredth/2, -$mag_width/2, -$mag_length/2), size=($mag_bredth, $mag_width, $mag_length)) in sph_5_7
  Box065 [NdFe38, oriented by sph_5_9] = box(corner=(-$mag_bredth/2, -$mag_width/2, -$mag_length/2), size=($mag_bredth, $mag_width, $mag_length)) in sph_5_9
  Box066 [NdFe38, oriented by sph_5_11] = box(corner=(-$mag_bredth/2, -$mag_width/2, -$mag_length/2), size=($mag_bredth, $mag_width, $mag_length)) in sph_5_11
  Box067 [NdFe38, oriented by sph_5_10] = box(corner=(-$mag_bredth/2, -$mag_width/2, -$mag_length/2), size=($mag_bredth, $mag_width, $mag_length)) in sph_5_10
  Box068 [NdFe38, oriented by sph_5_12] = box(corner=(-$mag_bredth/2, -$mag_width/2, -$mag_length/2), size=($mag_bredth, $mag_width, $mag_length)) in sph_5_12
  Box069 [NdFe38, oriented by sph_5_14] = box(corner=(-$mag_bredth/2, -$mag_width/2, -$mag_length/2), size=($mag_bredth, $mag_width, $mag_length)) in sph_5_14
  Box070 [NdFe38, oriented by sph_5_13] = box(corner=(-$mag_bredth/2, -$mag_width/2, -$mag_length/2), size=($mag_bredth, $mag_width, $mag_length)) in sph_5_13
  coordinate_system sph_6_13 = origin=(-sqrt($width**2*sin($angle2)**2), ($hieght*sqrt($width**2*cos($angle2)**2)/$width)*cos($Angle_between*13), -($hieght*sqrt($width**2*cos($angle2)**2)/$width)*sin($Angle_between*13)) x=(cos(2*$angle_elips2), sin(2*$angle_elips2)*cos($Angle_between*13), -sin(2*$angle_elips2)*sin($Angle_between*13)) y=(sin(2*$angle_elips1), -cos(2*$angle_elips1)*cos($Angle_between*13), cos(2*$angle_elips1)*sin($Angle_between*13)) in top
  Box071 [NdFe38, oriented by sph_7_12] = box(corner=(-$mag_bredth/2, -$mag_width/2, -$mag_length/2), size=($mag_bredth, $mag_width, $mag_length)) in sph_7_12
  Box072 [NdFe38, oriented by sph_7_15] = box(corner=(-$mag_bredth/2, -$mag_width/2, -$mag_length/2), size=($mag_bredth, $mag_width, $mag_length)) in sph_7_15
  Box073 [NdFe38, oriented by sph_7_14] = box(corner=(-$mag_bredth/2, -$mag_width/2, -$mag_length/2), size=($mag_bredth, $mag_width, $mag_length)) in sph_7_14
  Box074 [NdFe38, oriented by sph_7_13] = box(corner=(-$mag_bredth/2, -$mag_width/2, -$mag_length/2), size=($mag_bredth, $mag_width, $mag_length)) in sph_7_13
  Box075 [NdFe38, oriented by sph_7_11] = box(corner=(-$mag_bredth/2, -$mag_width/2, -$mag_length/2), size=($mag_bredth, $mag_width, $mag_length)) in sph_7_11
  Box077 [NdFe38] = box(corner=(-$mag_bredth/2, -$mag_width/2, -$mag_length/2), size=($mag_bredth, $mag_width, $mag_length)) in sph_7_7
  Box078 [NdFe38, oriented by sph_7_10] = box(corner=(-$mag_bredth/2, -$mag_width/2, -$mag_length/2), size=($mag_bredth, $mag_width, $mag_length)) in sph_7_10
  Box080 [NdFe38, oriented by sph_7_7] = box(corner=(-$mag_bredth/2, -$mag_width/2, -$mag_length/2), size=($mag_bredth, $mag_width, $mag_length)) in sph_7_7
  Box081 [NdFe38, oriented by sph_7_6] = box(corner=(-$mag_bredth/2, -$mag_width/2, -$mag_length/2), size=($mag_bredth, $mag_width, $mag_length)) in sph_7_6
  Box082 [NdFe38, oriented by sph_7_5] = box(corner=(-$mag_bredth/2, -$mag_width/2, -$mag_length/2), size=($mag_bredth, $mag_width, $mag_length)) in sph_7_5
  Box083 [NdFe38, oriented by sph_7_4] = box(corner=(-$mag_bredth/2, -$mag_width/2, -$mag_length/2), size=($mag_bredth, $mag_width, $mag_length)) in sph_7_4
  Box084 [NdFe38, oriented by sph_7_3] = box(corner=(-$mag_bredth/2, -$mag_width/2, -$mag_length/2), size=($mag_bredth, $mag_width, $mag_length)) in sph_7_3
  Box085 [NdFe38, oriented by sph_7_2] = box(corner=(-$mag_bredth/2, -$mag_width/2, -$mag_length/2), size=($mag_bredth, $mag_width, $mag_length)) in sph_7_2
  Box086 [NdFe38, oriented by sph_7_1] = box(corner=(-$mag_bredth/2, -$mag_width/2, -$mag_length/2), size=($mag_bredth, $mag_width, $mag_length)) in sph_7_1
  Box087 [NdFe38, oriented by sph_6_15] = box(corner=(-$mag_bredth/2, -$mag_width/2, -$mag_length/2), size=($mag_bredth, $mag_width, $mag_length)) in sph_6_15
  Box088 [NdFe38, oriented by sph_6_14] = box(corner=(-$mag_bredth/2, -$mag_width/2, -$mag_length/2), size=($mag_bredth, $mag_width, $mag_length)) in sph_6_14
  Box089 [NdFe38, oriented by sph_6_12] = box(corner=(-$mag_bredth/2, -$mag_width/2, -$mag_length/2), size=($mag_bredth, $mag_width, $mag_length)) in sph_6_12
  Box090 [NdFe38, oriented by sph_6_11] = box(corner=(-$mag_bredth/2, -$mag_width/2, -$mag_length/2), size=($mag_bredth, $mag_width, $mag_length)) in sph_6_11
  Box091 [NdFe38, oriented by sph_6_10] = box(corner=(-$mag_bredth/2, -$mag_width/2, -$mag_length/2), size=($mag_bredth, $mag_width, $mag_length)) in sph_6_10
  Box092 [NdFe38, oriented by sph_6_9] = box(corner=(-$mag_bredth/2, -$mag_width/2, -$mag_length/2), size=($mag_bredth, $mag_width, $mag_length)) in sph_6_9
  Box093 [NdFe38, oriented by sph_6_7] = box(corner=(-$mag_bredth/2, -$mag_width/2, -$mag_length/2), size=($mag_bredth, $mag_width, $mag_length)) in sph_6_7
  Box094 [NdFe38, oriented by sph_6_6] = box(corner=(-$mag_bredth/2, -$mag_width/2, -$mag_length/2), size=($mag_bredth, $mag_width, $mag_length)) in sph_6_6
  Box095 [NdFe38, oriented by sph_6_5] = box(corner=(-$mag_bredth/2, -$mag_width/2, -$mag_length/2), size=($mag_bredth, $mag_width, $mag_length)) in sph_6_5
  Box096 [NdFe38, oriented by sph_6_4] = box(corner=(-$mag_bredth/2, -$mag_width/2, -$mag_length/2), size=($mag_bredth, $mag_width, $mag_length)) in sph_6_4
  Box097 [NdFe38, oriented by sph_6_3] = box(corner=(-$mag_bredth/2, -$mag_width/2, -$mag_length/2), size=($mag_bredth, $mag_width, $mag_length)) in sph_6_3
  Box098 [NdFe38, oriented by sph_6_2] = box(corner=(-$mag_bredth/2, -$mag_width/2, -$mag_length/2), size=($mag_bredth, $mag_width, $mag_length)) in sph_6_2
  Box099 [NdFe38, oriented by sph_6_1] = box(corner=(-$mag_bredth/2, -$mag_width/2, -$mag_length/2), size=($mag_bredth, $mag_width, $mag_length)) in sph_6_1
  Box0100 [NdFe38, oriented by sph_6_13] = box(corner=(-$mag_bredth/2, -$mag_width/2, -$mag_length/2), size=($mag_bredth, $mag_width, $mag_length)) in sph_6_13
  coordinate_system sph_7_9 = origin=(-sqrt($width**2*sin($angle3)**2), ($hieght*sqrt($width**2*cos($angle3)**2)/$width)*cos($Angle_between*9), -($hieght*sqrt($width**2*cos($angle3)**2)/$width)*sin($Angle_between*9)) x=(cos(2*$angle_elips3), sin(2*$angle_elips3)*cos($Angle_between*9), -sin(2*$angle_elips3)*sin($Angle_between*9)) y=(sin(2*$angle_elips3), -cos(2*$angle_elips3)*cos($Angle_between*9), cos(2*$angle_elips3)*sin($Angle_between*9)) in top
  Box0101 [NdFe38, oriented by sph_7_9] = box(corner=(-$mag_bredth/2, -$mag_width/2, -$mag_length/2), size=($mag_bredth, $mag_width, $mag_length)) in sph_7_9
  group Box_Group = Box0..Box15, Box0_1..Box0_4, Box1_1..Box1_4, Box2_1..Box2_4, Box3_1..Box3_4, Box4_1..Box4_4, Box5_1..Box5_4, Box6_1..Box6_4, Box7_1..Box7_4, Box8_1..Box8_4, Box9_1..Box9_4, Box10_1..Box10_4, Box11_1..Box11_4, Box12_1..Box12_4, Box13_1..Box13_4, Box14_1..Box14_4, Box15_1..Box15_4, Box01, Box02, Box03, Box04, Box05, Box06, Box07, Box08, Box09, Box010, Box011, Box012, Box013, Box014, Box16, Box015, Box016, Box017, Box018, Box019, Box020, Box021, Box022, Box023, Box024, Box025, Box026, Box027, Box028, Box029, Box030, Box031, Box032, Box033, Box034, Box035, Box036, Box037, Box038, Box039, Box040, Box041, Box042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
  group Rectangle_Group = Rectangle1, Rectangle1_1..Rectangle1_15
mesh:
  Length1: LengthBased Objects=[Box0..Box15] NumMaxElem=10000
  initial mesh: GlobalCurvilinear{Apply}
setups:
  Setup1: Magnetostatic MaximumPasses=5 MinimumPasses=2 MinimumConvergedPasses=1 PercentRefinement=30 PercentError=1 NonLinearResidual=0.001
optimetrics:
  ParametricSetup1: Parametric disabled Sim._Setups=[Setup1]
    sweep $move_r: LIN 20 25 1
    calculate mean_sweet_spot on Setup1 : LastAdaptive
    calculate diffrens on Setup1 : LastAdaptive
  DefaultDesignXplorerSetup: DesignExplorer Sim._Setups=[Setup1] CostFunctionName=Cost CostFuncNormType=L2
    sweep $mag_bredth: 20mm
    sweep $mag_width: 10mm
    sweep $ratio_mod: 1
    sweep $length_between_row: 11mm
    sweep $move_r: 0mm
    table edits: del(20mm, 10mm, 1, 11mm, 0mm) add(9.05mm, 6.95mm, 1.455, 2.925mm, 22.6mm)
    calculate mean on Setup1 : LastAdaptive
    calculate ppmmath on Setup1 : LastAdaptive
    calculate ppmmax on Setup1 : LastAdaptive
field calculator expressions:
  mean = Mag_B | EnterVolume(sweet_spot_box) | VolumeValue | Mean
  min = Mag_B | EnterVolume(sweet_spot_box) | VolumeValue | Minimum
  max = Mag_B | EnterVolume(sweet_spot_box) | VolumeValue | Maximum
  diffmin = mean | min | - | Abs
  difmax = mean | max | - | Abs
  ppmmath = diffmin | mean | / | 1000000 | *
  ppmmax = difmax | mean | / | 1000000 | *
field plots:
  H_Vector1: H in sweet_spot_box on Setup1 : LastAdaptive
  Mag_B1, Mag_B2, B_Vector2, Mag_B3: B over a plane on Setup1 : LastAdaptive
  B_Vector1: B in sweet_spot_box on Setup1 : LastAdaptive
reports:
  Calculator Expressions Table 3: mean_sweet_spot vs $move_r on Setup1 : LastAdaptive
  Calculator Expressions Table 4: mean_sweet_spot, diffrens vs $move_r on Setup1 : LastAdaptive
