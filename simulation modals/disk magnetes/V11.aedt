# Ansys Electronics Desktop project, version 2020.2
project variables:
  $r = 30mm
  $mag_radis = 2.5mm
  $mag_length = 1.5mm
  $Angle_between = 0.39269908rad
  $angle1 = ($Angle_between*1*2) rad
  $angle2 = ($Angle_between*2*2) rad
  $angle3 = ($Angle_between*3*2) rad
  $angle4 = ($Angle_between*4*2) rad
  $angle5 = ($Angle_between*5*2) rad
  $angle6 = ($Angle_between*6*2) rad
  $angle7 = ($Angle_between*7*2) rad
  $angle8 = ($Angle_between*8*2) rad
  $angle9 = ($Angle_between*9*2) rad
  $angle10 = ($Angle_between*10*2) rad
  $angle11 = ($Angle_between*11*2) rad
  $angle12 = ($Angle_between*12*2) rad
  $angle13 = ($Angle_between*13*2) rad
  $angle14 = ($Angle_between*14*2) rad
  $angle15 = ($Angle_between*15*2) rad
  $sweet_spot = 40mm
  $swet_spot_length = 30mm
  $length_between_row = 1mm
  $num_of_rows = 10
materials:
  vacuum: permittivity=1
  NdFe30: permittivity=1 permeability=1.044573 conductivity=625000 magnetic_coercivity{Magnitude=-838000A_per_meter DirComp1=1 DirComp2=0 DirComp3=0} lande_g_factor=2
  NdFe35: permittivity=1 permeability=1.0997785 conductivity=625000 magnetic_coercivity{Magnitude=-890000A_per_meter DirComp1=1 DirComp2=0 DirComp3=0} lande_g_factor=2

design Maxwell3DDesign1 (Maxwell 3D, Magnetostatic, model units mm)
geometry:
  coordinate_system RelativeCS1 = origin=($r*cos($Angle_between*1), $r*sin($Angle_between*1), 0mm) x=(cos($angle1), sin($angle1), 0mm) y=(-sin($angle1), cos($angle1), 0mm)
  coordinate_system RelativeCS2 = origin=($r*cos($Angle_between*2), $r*sin($Angle_between*2), 0mm) x=(cos($angle2), sin($angle2), 0mm) y=(-sin($angle2), cos($angle2), 0mm)
  coordinate_system RelativeCS3 = origin=($r*cos($Angle_between*3), $r*sin($Angle_between*3), 0mm) x=(cos($angle3), sin($angle3), 0mm) y=(-sin($angle3), cos($angle3), 0mm)
  coordinate_system RelativeCS4 = origin=($r*cos($Angle_between*4), $r*sin($Angle_between*4), 0mm) x=(cos($angle4), sin($angle4), 0mm) y=(-sin($angle4), cos($angle4), 0mm)
  coordinate_system RelativeCS5 = origin=($r*cos($Angle_between*5), $r*sin($Angle_between*5), 0mm) x=(cos($angle5), sin($angle5), 0mm) y=(-5mm, 45mm, 0mm)
  coordinate_system RelativeCS6 = origin=($r*cos($Angle_between*6), $r*sin($Angle_between*6), 0mm) x=(cos($angle6), sin($angle6), 0mm) y=(-sin($angle6), cos($angle6), 0mm)
  coordinate_system RelativeCS7 = origin=($r*cos($Angle_between*7), $r*sin($Angle_between*7), 0mm) x=(cos($angle7), sin($angle7), 0mm) y=(-sin($angle7), cos($angle7), 0mm)
  coordinate_system RelativeCS8 = origin=($r*cos($Angle_between*8), $r*sin($Angle_between*8), 0mm) x=(cos($angle8), sin($angle8), 0mm) y=(-sin($angle8), cos($angle8), 0mm)
  coordinate_system RelativeCS9 = origin=($r*cos($Angle_between*9), $r*sin($Angle_between*9), 0mm) x=(cos($angle9), sin($angle9), 0mm) y=(-sin($angle9), cos($angle9), 0mm)
  coordinate_system RelativeCS10 = origin=($r*cos($Angle_between*10), $r*sin($Angle_between*10), 0mm) x=(cos($angle10), sin($angle10), 0mm) y=(-sin($angle10), cos($angle10), 0mm)
  coordinate_system RelativeCS11 = origin=($r*cos($Angle_between*11), $r*sin($Angle_between*11), 0mm) x=(cos($angle11), sin($angle11), 0mm) y=(-sin($angle11), cos($angle11), 0mm)
  coordinate_system RelativeCS12 = origin=($r*cos($Angle_between*12), $r*sin($Angle_between*12), 0mm) x=(cos($angle12), sin($angle12), 0mm) y=(-sin($angle12), cos($angle12), 0mm)
  coordinate_system RelativeCS13 = origin=($r*cos($Angle_between*13), $r*sin($Angle_between*13), 0mm) x=(cos($angle13), sin($angle13), 0mm) y=(-sin($angle13), cos($angle13), 0mm)
  coordinate_system RelativeCS14 = origin=($r*cos($Angle_between*14), $r*sin($Angle_between*14), 0mm) x=(cos($angle14), sin($angle14), 0mm) y=(-sin($angle14), cos($angle14), 0mm)
  coordinate_system RelativeCS15 = origin=($r*cos($Angle_between*15), $r*sin($Angle_between*15), 0mm) x=(cos($angle15), sin($angle15), 0mm) y=(-sin($angle15), cos($angle15), 0mm)
  coordinate_system RelativeCS0 = origin=($r*cos($Angle_between*0), $r*sin($Angle_between*0), 0mm) x=(cos(0) mm, sin(0) mm, 0mm) y=(-sin(0) mm, cos(0) mm, 0mm)
  coordinate_system center = origin=(0mm, 0mm, ($num_of_rows/2-0.5)*($mag_radis*2+$length_between_row)) x=(1mm, 0mm, 0mm) y=(0mm, 1mm, 0mm)
  sweet_spot_box [vacuum, non-model, oriented by center] = box(corner=(-$sweet_spot/2, -$sweet_spot/2, -$swet_spot_length/2), size=($sweet_spot, $sweet_spot, $swet_spot_length)) in center
  Region [vacuum] = region(percentage_offset=400 on all sides) in center
  point Point1 = (-110000mm, -90000mm, 0mm)
  Cylinder1 [NdFe35] = cylinder(axis=X, base_centre=(0mm, 0mm, 0mm), radius=$mag_radis, height=$mag_length) in RelativeCS0
  Cylinder2 [NdFe35] = cylinder(axis=X, base_centre=(0mm, 0mm, 0mm), radius=$mag_radis, height=$mag_length) in RelativeCS1
  Cylinder3 [NdFe35] = cylinder(axis=X, base_centre=(0mm, 0mm, 0mm), radius=$mag_radis, height=$mag_length) in RelativeCS2
  Cylinder4 [NdFe35] = cylinder(axis=X, base_centre=(0mm, 0mm, 0mm), radius=$mag_radis, height=$mag_length) in RelativeCS3
  Cylinder5 [NdFe35] = cylinder(axis=X, base_centre=(0mm, 0mm, 0mm), radius=$mag_radis, height=$mag_length) in RelativeCS4
  Cylinder6 [NdFe35] = cylinder(axis=X, base_centre=(0mm, 0mm, 0mm), radius=$mag_radis, height=$mag_length) in RelativeCS5
  Cylinder7 [NdFe35] = cylinder(axis=X, base_centre=(0mm, 0mm, 0mm), radius=$mag_radis, height=$mag_length) in RelativeCS6
  Cylinder8 [NdFe35] = cylinder(axis=X, base_centre=(0mm, 0mm, 0mm), radius=$mag_radis, height=$mag_length) in RelativeCS7
  Cylinder9 [NdFe35] = cylinder(axis=X, base_centre=(0mm, 0mm, 0mm), radius=$mag_radis, height=$mag_length) in RelativeCS8
  Cylinder10 [NdFe35] = cylinder(axis=X, base_centre=(0mm, 0mm, 0mm), radius=$mag_radis, height=$mag_length) in RelativeCS9
  Cylinder11 [NdFe35] = cylinder(axis=X, base_centre=(0mm, 0mm, 0mm), radius=$mag_radis, height=$mag_length) in RelativeCS10
  Cylinder12 [NdFe35] = cylinder(axis=X, base_centre=(0mm, 0mm, 0mm), radius=$mag_radis, height=$mag_length) in RelativeCS11
  Cylinder13 [NdFe35] = cylinder(axis=X, base_centre=(0mm, 0mm, 0mm), radius=$mag_radis, height=$mag_length) in RelativeCS12
  Cylinder14 [NdFe35] = cylinder(axis=X, base_centre=(0mm, 0mm, 0mm), radius=$mag_radis, height=$mag_length) in RelativeCS13
  Cylinder15 [NdFe35] = cylinder(axis=X, base_centre=(0mm, 0mm, 0mm), radius=$mag_radis, height=$mag_length) in RelativeCS14
  Cylinder16 [NdFe35] = cylinder(axis=X, base_centre=(0mm, 0mm, 0mm), radius=$mag_radis, height=$mag_length) in RelativeCS15
  Cylinder11_1..Cylinder11_9 [NdFe35] = Cylinder11.duplicate_along_line(step=(0mm, 0mm, $mag_radis*2+$length_between_row), total=10)
  Cylinder1_1..Cylinder1_9 [NdFe35] = Cylinder1.duplicate_along_line(step=(0mm, 0mm, $mag_radis*2+$length_between_row), total=10)
  Cylinder2_1..Cylinder2_9 [NdFe35] = Cylinder2.duplicate_along_line(step=(0mm, 0mm, $mag_radis*2+$length_between_row), total=10)
  Cylinder3_1..Cylinder3_9 [NdFe35] = Cylinder3.duplicate_along_line(step=(0mm, 0mm, $mag_radis*2+$length_between_row), total=10)
  Cylinder4_1..Cylinder4_9 [NdFe35] = Cylinder4.duplicate_along_line(step=(0mm, 0mm, $mag_radis*2+$length_between_row), total=10)
  Cylinder5_1..Cylinder5_9 [NdFe35] = Cylinder5.duplicate_along_line(step=(0mm, 0mm, $mag_radis*2+$length_between_row), total=10)
  Cylinder6_1..Cylinder6_9 [NdFe35] = Cylinder6.duplicate_along_line(step=(0mm, 0mm, $mag_radis*2+$length_between_row), total=10)
  Cylinder7_1..Cylinder7_9 [NdFe35] = Cylinder7.duplicate_along_line(step=(0mm, 0mm, $mag_radis*2+$length_between_row), total=10)
  Cylinder8_1..Cylinder8_9 [NdFe35] = Cylinder8.duplicate_along_line(step=(0mm, 0mm, $mag_radis*2+$length_between_row), total=10)
  Cylinder9_1..Cylinder9_9 [NdFe35] = Cylinder9.duplicate_along_line(step=(0mm, 0mm, $mag_radis*2+$length_between_row), total=10)
  Cylinder10_1..Cylinder10_9 [NdFe35] = Cylinder10.duplicate_along_line(step=(0mm, 0mm, $mag_radis*2+$length_between_row), total=10)
  Cylinder12_1..Cylinder12_9 [NdFe35] = Cylinder12.duplicate_along_line(step=(0mm, 0mm, $mag_radis*2+$length_between_row), total=10)
  Cylinder13_1..Cylinder13_9 [NdFe35] = Cylinder13.duplicate_along_line(step=(0mm, 0mm, $mag_radis*2+$length_between_row), total=10)
  Cylinder14_1..Cylinder14_9 [NdFe35] = Cylinder14.duplicate_along_line(step=(0mm, 0mm, $mag_radis*2+$length_between_row), total=10)
  Cylinder15_1..Cylinder15_9 [NdFe35] = Cylinder15.duplicate_along_line(step=(0mm, 0mm, $mag_radis*2+$length_between_row), total=10)
  Cylinder16_1..Cylinder16_9 [NdFe35] = Cylinder16.duplicate_along_line(step=(0mm, 0mm, $mag_radis*2+$length_between_row), total=10)
mesh:
  initial mesh: GlobalCurvilinear{Apply}
setups:
  solution1: Magnetostatic MaximumPasses=10 MinimumPasses=2 MinimumConvergedPasses=1 PercentRefinement=30 PercentError=1 NonLinearResidual=0.001 SmoothBHCurve
optimetrics:
  ParametricSetup1: Parametric Sim._Setups=[solution1]
    sweep $r: LIN 30mm 50mm 5mm
    calculate mean on solution1 : LastAdaptive
    calculate min on solution1 : LastAdaptive
    calculate max on solution1 : LastAdaptive
    calculate diff on solution1 : LastAdaptive
field calculator expressions:
  mean = Mag_B | EnterVolume(sweet_spot_box) | VolumeValue | Mean
  min = Mag_B | EnterVolume(sweet_spot_box) | VolumeValue | Minimum
  max = Mag_B | EnterVolume(sweet_spot_box) | VolumeValue | Maximum
  diff = min | max | -
field plots:
  B_Vector1: B in sweet_spot_box on solution1 : LastAdaptive
reports:
  Calculator Expressions Table 1: mean, min, max, diff vs $r on solution1 : LastAdaptive
